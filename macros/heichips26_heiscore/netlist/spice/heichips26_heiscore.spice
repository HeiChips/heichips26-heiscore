* NGSPICE file created from heichips26_heiscore.ext - technology: ihp-sg13cmos5l

* Black-box entry subcircuit for sg13cmos5l_xnor2_1 abstract view
.subckt sg13cmos5l_xnor2_1 Y A B VDD VSS
.ends

* Black-box entry subcircuit for sg13cmos5l_nand3_1 abstract view
.subckt sg13cmos5l_nand3_1 Y A B C VDD VSS
.ends

* Black-box entry subcircuit for sg13cmos5l_nor2_1 abstract view
.subckt sg13cmos5l_nor2_1 Y A B VDD VSS
.ends

* Black-box entry subcircuit for sg13cmos5l_nor2b_1 abstract view
.subckt sg13cmos5l_nor2b_1 Y A B_N VDD VSS
.ends

* Black-box entry subcircuit for sg13cmos5l_fill_1 abstract view
.subckt sg13cmos5l_fill_1 VDD VSS
.ends

* Black-box entry subcircuit for sg13cmos5l_or2_1 abstract view
.subckt sg13cmos5l_or2_1 X A B VDD VSS
.ends

* Black-box entry subcircuit for sg13cmos5l_dlygate4sd3_1 abstract view
.subckt sg13cmos5l_dlygate4sd3_1 X A VDD VSS
.ends

* Black-box entry subcircuit for sg13cmos5l_decap_8 abstract view
.subckt sg13cmos5l_decap_8 VDD VSS
.ends

* Black-box entry subcircuit for sg13cmos5l_nand2b_1 abstract view
.subckt sg13cmos5l_nand2b_1 Y A_N B VDD VSS
.ends

* Black-box entry subcircuit for sg13cmos5l_buf_1 abstract view
.subckt sg13cmos5l_buf_1 X A VDD VSS
.ends

* Black-box entry subcircuit for sg13cmos5l_a22oi_1 abstract view
.subckt sg13cmos5l_a22oi_1 Y A1 A2 B1 B2 VDD VSS
.ends

* Black-box entry subcircuit for sg13cmos5l_decap_4 abstract view
.subckt sg13cmos5l_decap_4 VDD VSS
.ends

* Black-box entry subcircuit for sg13cmos5l_nor4_1 abstract view
.subckt sg13cmos5l_nor4_1 Y A B C D VDD VSS
.ends

* Black-box entry subcircuit for sg13cmos5l_fill_2 abstract view
.subckt sg13cmos5l_fill_2 VDD VSS
.ends

* Black-box entry subcircuit for sg13cmos5l_buf_8 abstract view
.subckt sg13cmos5l_buf_8 X A VDD VSS
.ends

* Black-box entry subcircuit for sg13cmos5l_o21ai_1 abstract view
.subckt sg13cmos5l_o21ai_1 Y A1 A2 B1 VDD VSS
.ends

* Black-box entry subcircuit for sg13cmos5l_a21o_1 abstract view
.subckt sg13cmos5l_a21o_1 X A1 A2 B1 VDD VSS
.ends

* Black-box entry subcircuit for sg13cmos5l_inv_1 abstract view
.subckt sg13cmos5l_inv_1 Y A VDD VSS
.ends

* Black-box entry subcircuit for sg13cmos5l_nand2_1 abstract view
.subckt sg13cmos5l_nand2_1 Y A B VDD VSS
.ends

* Black-box entry subcircuit for sg13cmos5l_and2_1 abstract view
.subckt sg13cmos5l_and2_1 X A B VDD VSS
.ends

* Black-box entry subcircuit for sg13cmos5l_dfrbpq_1 abstract view
.subckt sg13cmos5l_dfrbpq_1 Q CLK D RESET_B VDD VSS
.ends

* Black-box entry subcircuit for sg13cmos5l_nand4_1 abstract view
.subckt sg13cmos5l_nand4_1 Y A B C D VDD VSS
.ends

* Black-box entry subcircuit for sg13cmos5l_tiehi abstract view
.subckt sg13cmos5l_tiehi L_HI VDD VSS
.ends

* Black-box entry subcircuit for sg13cmos5l_nor3_1 abstract view
.subckt sg13cmos5l_nor3_1 Y A B C VDD VSS
.ends

* Black-box entry subcircuit for sg13cmos5l_a221oi_1 abstract view
.subckt sg13cmos5l_a221oi_1 Y A1 A2 B1 B2 C1 VDD VSS
.ends

* Black-box entry subcircuit for sg13cmos5l_mux2_1 abstract view
.subckt sg13cmos5l_mux2_1 X A0 A1 S VDD VSS
.ends

* Black-box entry subcircuit for sg13cmos5l_a21oi_1 abstract view
.subckt sg13cmos5l_a21oi_1 Y A1 A2 B1 VDD VSS
.ends

* Black-box entry subcircuit for sg13cmos5l_or4_1 abstract view
.subckt sg13cmos5l_or4_1 X A B C D VDD VSS
.ends

* Black-box entry subcircuit for sg13cmos5l_xor2_1 abstract view
.subckt sg13cmos5l_xor2_1 X A B VDD VSS
.ends

* Black-box entry subcircuit for sg13cmos5l_and3_1 abstract view
.subckt sg13cmos5l_and3_1 X A B C VDD VSS
.ends

* Black-box entry subcircuit for sg13cmos5l_nand3b_1 abstract view
.subckt sg13cmos5l_nand3b_1 Y A_N B C VDD VSS
.ends

* Black-box entry subcircuit for sg13cmos5l_and4_1 abstract view
.subckt sg13cmos5l_and4_1 X A B C D VDD VSS
.ends

* Black-box entry subcircuit for sg13cmos5l_or3_1 abstract view
.subckt sg13cmos5l_or3_1 X A B C VDD VSS
.ends

* Black-box entry subcircuit for sg13cmos5l_tielo abstract view
.subckt sg13cmos5l_tielo L_LO VDD VSS
.ends

.subckt heichips26_heiscore VGND VPWR clk ena rst_n ui_in[0] ui_in[1] ui_in[2] ui_in[3]
+ ui_in[4] ui_in[5] ui_in[6] ui_in[7] uio_in[0] uio_in[1] uio_in[2] uio_in[3] uio_in[4]
+ uio_in[5] uio_in[6] uio_in[7] uio_oe[0] uio_oe[1] uio_oe[2] uio_oe[3] uio_oe[4]
+ uio_oe[5] uio_oe[6] uio_oe[7] uio_out[0] uio_out[1] uio_out[2] uio_out[3] uio_out[4]
+ uio_out[5] uio_out[6] uio_out[7] uo_out[0] uo_out[1] uo_out[2] uo_out[3] uo_out[4]
+ uo_out[5] uo_out[6] uo_out[7]
X_2037_ _3224_/B _2037_/A _2049_/B VPWR VGND sg13cmos5l_xnor2_1
X_2106_ _2892_/A _2874_/B _2882_/A _2106_/C VPWR VGND sg13cmos5l_nand3_1
X_3155_ _3156_/D _3235_/A _3217_/D VPWR VGND sg13cmos5l_nor2_1
X_3086_ _3217_/C _3272_/A _3272_/B VPWR VGND sg13cmos5l_nor2b_1
XFILLER_10_339 VPWR VGND sg13cmos5l_fill_1
X_2939_ _2942_/B _2939_/A _2939_/B VPWR VGND sg13cmos5l_or2_1
Xhold362 hold362/X _3327_/Q VPWR VGND sg13cmos5l_dlygate4sd3_1
Xhold351 hold351/X _3308_/Q VPWR VGND sg13cmos5l_dlygate4sd3_1
Xhold340 hold340/X _3311_/Q VPWR VGND sg13cmos5l_dlygate4sd3_1
Xhold373 hold373/X _3329_/Q VPWR VGND sg13cmos5l_dlygate4sd3_1
XFILLER_13_133 VPWR VGND sg13cmos5l_fill_1
XFILLER_45_236 VPWR VGND sg13cmos5l_fill_1
XFILLER_42_62 VPWR VGND sg13cmos5l_decap_8
XFILLER_5_365 VPWR VGND sg13cmos5l_fill_1
XFILLER_36_236 VPWR VGND sg13cmos5l_decap_8
X_2724_ _2727_/B _3363_/Q _2738_/B VPWR VGND sg13cmos5l_nand2b_1
X_2655_ _2656_/C _2655_/A _2666_/A _2663_/A VPWR VGND sg13cmos5l_nand3_1
Xfanout105 _3181_/B _3371_/Q VPWR VGND sg13cmos5l_buf_1
Xfanout116 _2023_/A _3342_/Q VPWR VGND sg13cmos5l_buf_1
Xfanout127 _2634_/A hold353/X VPWR VGND sg13cmos5l_buf_1
Xfanout138 _2037_/A _2575_/A VPWR VGND sg13cmos5l_buf_1
Xfanout149 _3014_/A _3307_/Q VPWR VGND sg13cmos5l_buf_1
X_3207_ _3207_/Y _3208_/A _3208_/B _2069_/B _3229_/A VPWR VGND sg13cmos5l_a22oi_1
X_2586_ _2586_/Y _2586_/A _3288_/B VPWR VGND sg13cmos5l_xnor2_1
XFILLER_27_203 VPWR VGND sg13cmos5l_decap_4
XFILLER_27_258 VPWR VGND sg13cmos5l_fill_1
X_3138_ _3138_/Y _3138_/A _3138_/B _3138_/C _3138_/D VPWR VGND sg13cmos5l_nor4_1
X_3069_ _3069_/Y _3066_/A _3091_/A _3067_/Y _3068_/Y VPWR VGND sg13cmos5l_a22oi_1
XFILLER_2_379 VPWR VGND sg13cmos5l_fill_1
XFILLER_37_62 VPWR VGND sg13cmos5l_decap_4
XFILLER_37_95 VPWR VGND sg13cmos5l_decap_8
XFILLER_5_173 VPWR VGND sg13cmos5l_fill_1
X_2440_ _2441_/D _2539_/A _2541_/B _2535_/C VPWR VGND sg13cmos5l_nand3_1
X_2371_ _2372_/C _2510_/C _2371_/B VPWR VGND sg13cmos5l_nor2_1
XFILLER_20_401 VPWR VGND sg13cmos5l_fill_2
XFILLER_32_250 VPWR VGND sg13cmos5l_fill_2
Xclkbuf_4_12_0_clk clkbuf_4_12_0_clk/X clkbuf_0_clk/X VPWR VGND sg13cmos5l_buf_8
X_2707_ _2707_/Y _2705_/Y _2706_/Y _2748_/A VPWR VGND sg13cmos5l_o21ai_1
X_2638_ _3337_/D _2634_/A _2671_/A2 _2637_/Y VPWR VGND sg13cmos5l_a21o_1
X_2569_ _2569_/Y _2564_/Y _2568_/X _2460_/Y VPWR VGND sg13cmos5l_o21ai_1
XFILLER_15_217 VPWR VGND sg13cmos5l_decap_8
XFILLER_23_250 VPWR VGND sg13cmos5l_fill_2
XFILLER_23_294 VPWR VGND sg13cmos5l_decap_8
X_1871_ _1871_/Y _2318_/A _3190_/B _1888_/B VPWR VGND sg13cmos5l_o21ai_1
X_1940_ _1940_/Y _1940_/A VPWR VGND sg13cmos5l_inv_1
X_2423_ _2424_/B _2526_/A _2423_/B VPWR VGND sg13cmos5l_nor2_1
X_2285_ _2320_/B _2634_/A _2289_/B VPWR VGND sg13cmos5l_xnor2_1
X_2354_ _2400_/B _2354_/A _2540_/C VPWR VGND sg13cmos5l_nand2_1
XFILLER_20_242 VPWR VGND sg13cmos5l_decap_8
XFILLER_28_364 VPWR VGND sg13cmos5l_fill_2
XFILLER_47_106 VPWR VGND sg13cmos5l_decap_8
XFILLER_7_268 VPWR VGND sg13cmos5l_fill_1
X_2070_ _2071_/B _2067_/Y _2069_/Y _2063_/Y VPWR VGND sg13cmos5l_o21ai_1
XFILLER_19_386 VPWR VGND sg13cmos5l_fill_1
X_2972_ _2972_/Y _2972_/A _2984_/B VPWR VGND sg13cmos5l_xnor2_1
X_1785_ _2049_/A _2037_/A _1999_/B VPWR VGND sg13cmos5l_nor2_1
X_1854_ _1856_/B _1905_/B _1941_/B VPWR VGND sg13cmos5l_xnor2_1
X_1923_ _2438_/B _2098_/A _1924_/B VPWR VGND sg13cmos5l_and2_1
XFILLER_39_19 VPWR VGND sg13cmos5l_decap_8
X_3386_ _3386_/Q _3388_/CLK _3386_/D fanout171/X VPWR VGND sg13cmos5l_dfrbpq_1
X_2406_ _2449_/A _2503_/B _2406_/B VPWR VGND sg13cmos5l_and2_1
XFILLER_29_128 VPWR VGND sg13cmos5l_decap_8
X_2199_ _2200_/B _2524_/A _2443_/B _2520_/C _2371_/B VPWR VGND sg13cmos5l_nor4_1
X_2268_ _2506_/A _2418_/A _2352_/A VPWR VGND sg13cmos5l_nand2_1
X_2337_ _2337_/X _3301_/Q _2337_/B VPWR VGND sg13cmos5l_or2_1
XFILLER_28_194 VPWR VGND sg13cmos5l_fill_1
XFILLER_43_175 VPWR VGND sg13cmos5l_decap_8
XFILLER_45_73 VPWR VGND sg13cmos5l_fill_2
X_3240_ _3240_/Y _3388_/Q _3240_/B VPWR VGND sg13cmos5l_nor2_1
X_2053_ _2071_/A _1981_/B _2002_/B _2054_/A VPWR VGND sg13cmos5l_a21o_1
X_2122_ _2446_/D _2213_/B _2157_/A VPWR VGND sg13cmos5l_nor2_1
X_3171_ _3173_/A _3347_/Q _3171_/B _3171_/C _3171_/D VPWR VGND sg13cmos5l_nand4_1
XFILLER_19_194 VPWR VGND sg13cmos5l_decap_4
X_2955_ _2955_/Y _2980_/A _2955_/B VPWR VGND sg13cmos5l_nand2_1
X_1768_ _1773_/A _2633_/A _2028_/A _1865_/B _1768_/D VPWR VGND sg13cmos5l_nand4_1
X_1837_ _1837_/Y _1933_/B _3190_/B _1823_/B _3015_/A VPWR VGND sg13cmos5l_a22oi_1
X_1906_ _1906_/Y _1804_/Y _2023_/B _1905_/Y VPWR VGND sg13cmos5l_o21ai_1
X_2886_ _2886_/Y _2886_/A _2889_/C VPWR VGND sg13cmos5l_nand2_1
X_1699_ _2269_/B input5/X VPWR VGND sg13cmos5l_inv_1
X_3369_ _3369_/Q _3416_/CLK _3369_/D fanout166/X VPWR VGND sg13cmos5l_dfrbpq_1
XFILLER_15_98 VPWR VGND sg13cmos5l_fill_2
XFILLER_9_308 VPWR VGND sg13cmos5l_decap_4
X_3414__204 _3414_/D VPWR VGND sg13cmos5l_tiehi
Xoutput7 uo_out[1] _3448_/X VPWR VGND sg13cmos5l_buf_1
XFILLER_31_123 VPWR VGND sg13cmos5l_decap_8
Xclkbuf_5_17__f_clk clkload4/A clkbuf_4_8_0_clk/X VPWR VGND sg13cmos5l_buf_8
X_2740_ _2740_/X _2740_/A _2740_/B VPWR VGND sg13cmos5l_or2_1
X_2671_ _2671_/X hold296/X _2671_/A2 _2670_/Y VPWR VGND sg13cmos5l_a21o_1
X_3223_ _3223_/Y _3224_/A _3224_/B VPWR VGND sg13cmos5l_nand2_1
XFILLER_11_0 VPWR VGND sg13cmos5l_fill_2
X_2036_ _2040_/C _2062_/A _3329_/Q VPWR VGND sg13cmos5l_nor2_1
X_2105_ _2106_/C _3397_/Q _3398_/Q _3399_/Q VPWR VGND sg13cmos5l_nor3_1
X_3154_ _3217_/D _3164_/D _3165_/A _3208_/A VPWR VGND sg13cmos5l_nor3_1
X_3085_ _3087_/C _3136_/B _3171_/B VPWR VGND sg13cmos5l_nor2_1
X_2938_ _2939_/B _2984_/A _3115_/A _2938_/C VPWR VGND sg13cmos5l_nand3_1
Xhold374 hold374/X _3309_/Q VPWR VGND sg13cmos5l_dlygate4sd3_1
Xhold363 hold363/X _3295_/Q VPWR VGND sg13cmos5l_dlygate4sd3_1
Xhold352 hold352/X _3310_/Q VPWR VGND sg13cmos5l_dlygate4sd3_1
Xhold341 _3311_/D _3043_/Y VPWR VGND sg13cmos5l_dlygate4sd3_1
Xhold330 _3274_/A _3322_/Q VPWR VGND sg13cmos5l_dlygate4sd3_1
X_2869_ _2869_/Y _3390_/Q _2892_/B _2867_/B VPWR VGND sg13cmos5l_o21ai_1
X_2723_ _2732_/B _2728_/C VPWR VGND sg13cmos5l_inv_1
X_2654_ _2658_/B _2655_/A _2666_/A _2663_/A VPWR VGND sg13cmos5l_a21o_1
X_2585_ _2585_/Y _2068_/A _3288_/B _2592_/A VPWR VGND sg13cmos5l_o21ai_1
Xfanout106 _3269_/C hold375/X VPWR VGND sg13cmos5l_buf_1
Xfanout117 _2032_/A _3341_/Q VPWR VGND sg13cmos5l_buf_1
Xfanout128 _2628_/A _1816_/B VPWR VGND sg13cmos5l_buf_1
Xfanout139 _2575_/A hold350/X VPWR VGND sg13cmos5l_buf_1
X_3206_ _3206_/Y _3229_/A _2069_/B _3205_/Y VPWR VGND sg13cmos5l_o21ai_1
X_3137_ _3138_/D _3137_/A _3144_/A VPWR VGND sg13cmos5l_nand2_1
X_2019_ _2019_/Y _2013_/Y _2017_/Y _2018_/Y VPWR VGND sg13cmos5l_o21ai_1
X_3068_ _3068_/Y _1933_/B _3145_/A _3052_/Y _3056_/Y _3066_/Y VPWR VGND sg13cmos5l_a221oi_1
XFILLER_18_259 VPWR VGND sg13cmos5l_fill_1
XFILLER_33_207 VPWR VGND sg13cmos5l_decap_8
XFILLER_33_218 VPWR VGND sg13cmos5l_fill_2
XFILLER_37_52 VPWR VGND sg13cmos5l_fill_1
XFILLER_37_85 VPWR VGND sg13cmos5l_decap_4
X_2370_ _2541_/B _2370_/A _2370_/B VPWR VGND sg13cmos5l_nand2_1
XFILLER_17_292 VPWR VGND sg13cmos5l_fill_1
X_2706_ _2706_/Y _2706_/A _3357_/Q VPWR VGND sg13cmos5l_nor2b_1
X_2637_ _2637_/Y _2642_/A _2637_/B VPWR VGND sg13cmos5l_nor2_1
X_2568_ _2568_/X _2527_/B _2565_/Y _2568_/S VPWR VGND sg13cmos5l_mux2_1
X_2499_ _2500_/D _2499_/A _2499_/B _2499_/C _2524_/B VPWR VGND sg13cmos5l_nor4_1
XFILLER_48_40 VPWR VGND sg13cmos5l_decap_8
XFILLER_48_62 VPWR VGND sg13cmos5l_fill_2
X_1870_ _1888_/B _1862_/B _1862_/C _3098_/A VPWR VGND sg13cmos5l_o21ai_1
X_2422_ _2423_/B _2439_/A _2449_/A _2422_/C VPWR VGND sg13cmos5l_nand3_1
X_2353_ _2486_/A _2444_/B _1917_/Y _2457_/C VPWR VGND sg13cmos5l_a21oi_1
X_2284_ _2303_/A _2294_/B _2315_/C _3054_/A VPWR VGND sg13cmos5l_a21o_1
X_1999_ _2060_/D _3328_/Q _1999_/B _2046_/C VPWR VGND sg13cmos5l_nand3_1
XFILLER_47_118 VPWR VGND sg13cmos5l_decap_8
XFILLER_28_310 VPWR VGND sg13cmos5l_fill_2
XFILLER_47_129 VPWR VGND sg13cmos5l_fill_2
XFILLER_11_287 VPWR VGND sg13cmos5l_decap_8
XFILLER_34_42 VPWR VGND sg13cmos5l_fill_2
XFILLER_38_107 VPWR VGND sg13cmos5l_decap_8
Xclkbuf_4_11_0_clk clkbuf_4_11_0_clk/X clkbuf_0_clk/X VPWR VGND sg13cmos5l_buf_8
XFILLER_19_398 VPWR VGND sg13cmos5l_decap_4
X_1922_ _2436_/A _2134_/B _2158_/B VPWR VGND sg13cmos5l_nand2_1
X_2971_ _2971_/Y _2971_/A _2984_/B VPWR VGND sg13cmos5l_xnor2_1
X_1784_ _2351_/C _3333_/Q _2063_/A _1760_/Y _1783_/X VPWR VGND sg13cmos5l_a22oi_1
X_1853_ _1859_/B _1853_/A _1853_/B VPWR VGND sg13cmos5l_nand2_1
XFILLER_29_107 VPWR VGND sg13cmos5l_decap_8
XFILLER_41_0 VPWR VGND sg13cmos5l_decap_8
X_2336_ _2336_/Y _3301_/Q _2337_/B _2334_/Y _2335_/Y _2318_/Y VPWR VGND sg13cmos5l_a221oi_1
X_3454_ _3454_/X _3454_/A VPWR VGND sg13cmos5l_buf_1
X_3385_ _3385_/Q _3388_/CLK _3385_/D fanout171/X VPWR VGND sg13cmos5l_dfrbpq_1
X_2405_ _2406_/B _2405_/A _2405_/B VPWR VGND sg13cmos5l_nor2_1
XFILLER_37_173 VPWR VGND sg13cmos5l_decap_8
X_2198_ _2518_/A _2450_/A _2198_/B VPWR VGND sg13cmos5l_nand2_1
X_2267_ _2276_/A _2267_/A _2389_/A _2361_/B _2267_/D VPWR VGND sg13cmos5l_or4_1
XFILLER_40_338 VPWR VGND sg13cmos5l_fill_1
XFILLER_29_31 VPWR VGND sg13cmos5l_fill_2
XFILLER_29_75 VPWR VGND sg13cmos5l_fill_2
XFILLER_16_346 VPWR VGND sg13cmos5l_fill_1
XFILLER_24_390 VPWR VGND sg13cmos5l_fill_1
XFILLER_28_151 VPWR VGND sg13cmos5l_fill_2
X_3170_ _3170_/Y _3166_/Y _3167_/Y _3169_/Y VPWR VGND sg13cmos5l_a21oi_1
XFILLER_19_140 VPWR VGND sg13cmos5l_decap_4
XFILLER_19_162 VPWR VGND sg13cmos5l_decap_8
XFILLER_34_110 VPWR VGND sg13cmos5l_fill_2
X_2052_ _2052_/X _2052_/A _2052_/B VPWR VGND sg13cmos5l_and2_1
X_2121_ _2430_/A _2538_/A _2467_/A VPWR VGND sg13cmos5l_nor2_1
XFILLER_34_165 VPWR VGND sg13cmos5l_decap_4
X_1905_ _1905_/Y _1886_/B _1905_/B VPWR VGND sg13cmos5l_nand2b_1
X_2954_ _2955_/B _2951_/Y _2954_/B VPWR VGND sg13cmos5l_nand2b_1
X_2885_ _2889_/C _2885_/A _2885_/B _2885_/C _2885_/D VPWR VGND sg13cmos5l_or4_1
X_1698_ _2874_/A _3367_/Q VPWR VGND sg13cmos5l_inv_1
X_1767_ _1767_/Y _1934_/A _1937_/A VPWR VGND sg13cmos5l_nand2_1
X_1836_ _1856_/A _1836_/A _1836_/B VPWR VGND sg13cmos5l_nand2_1
X_2319_ _2319_/Y _2963_/A _2319_/B VPWR VGND sg13cmos5l_xnor2_1
X_3368_ _3368_/Q clkload4/A _3368_/D fanout172/X VPWR VGND sg13cmos5l_dfrbpq_1
X_3299_ _3299_/Q clkload2/A _3299_/D fanout176/X VPWR VGND sg13cmos5l_dfrbpq_1
XFILLER_25_132 VPWR VGND sg13cmos5l_fill_2
XFILLER_40_135 VPWR VGND sg13cmos5l_fill_2
XFILLER_31_54 VPWR VGND sg13cmos5l_fill_2
Xoutput8 uo_out[2] _3449_/X VPWR VGND sg13cmos5l_buf_1
Xoutput10 uo_out[4] _3451_/X VPWR VGND sg13cmos5l_buf_1
XFILLER_16_187 VPWR VGND sg13cmos5l_decap_8
XFILLER_31_146 VPWR VGND sg13cmos5l_fill_1
XFILLER_8_342 VPWR VGND sg13cmos5l_fill_1
XFILLER_8_375 VPWR VGND sg13cmos5l_fill_2
X_2670_ _2670_/Y _2670_/A _2670_/B VPWR VGND sg13cmos5l_nor2_1
X_2104_ _2882_/A _3394_/Q _3395_/Q _2885_/B VPWR VGND sg13cmos5l_nor3_1
X_3222_ _3257_/B _3222_/A _3221_/Y VPWR VGND sg13cmos5l_nor2b_1
X_3153_ _3156_/C _3168_/C _3152_/Y _3143_/Y VPWR VGND sg13cmos5l_a21oi_1
X_2035_ _2072_/B _2033_/Y _2034_/Y _1886_/Y VPWR VGND sg13cmos5l_o21ai_1
X_3084_ _3171_/B _3144_/A _2810_/B _3138_/B VPWR VGND sg13cmos5l_o21ai_1
XFILLER_10_308 VPWR VGND sg13cmos5l_decap_4
XFILLER_10_319 VPWR VGND sg13cmos5l_decap_4
X_2937_ _2938_/C _2318_/A _2936_/Y _2971_/A VPWR VGND sg13cmos5l_o21ai_1
X_2868_ _2870_/A _2932_/B _2871_/C VPWR VGND sg13cmos5l_nor2_1
X_1819_ _1819_/Y _1817_/X _1818_/X _1815_/X VPWR VGND sg13cmos5l_o21ai_1
Xhold375 hold375/X _3370_/Q VPWR VGND sg13cmos5l_dlygate4sd3_1
Xhold364 hold364/X _3378_/Q VPWR VGND sg13cmos5l_dlygate4sd3_1
Xhold353 hold353/X _3337_/Q VPWR VGND sg13cmos5l_dlygate4sd3_1
Xhold342 _1669_/A _3304_/Q VPWR VGND sg13cmos5l_dlygate4sd3_1
Xhold331 _2600_/A _3331_/Q VPWR VGND sg13cmos5l_dlygate4sd3_1
Xhold320 _3394_/D _2879_/Y VPWR VGND sg13cmos5l_dlygate4sd3_1
X_2799_ _3371_/D _3269_/B _2806_/A _2798_/Y VPWR VGND sg13cmos5l_a21o_1
Xclkbuf_5_23__f_clk _3423_/CLK clkbuf_4_11_0_clk/X VPWR VGND sg13cmos5l_buf_8
XFILLER_42_86 VPWR VGND sg13cmos5l_fill_2
XFILLER_5_378 VPWR VGND sg13cmos5l_fill_1
X_2722_ _2728_/C _2722_/A _2722_/B VPWR VGND sg13cmos5l_nor2_1
Xfanout107 _2769_/B hold359/X VPWR VGND sg13cmos5l_buf_1
Xfanout118 _2665_/A1 _3341_/Q VPWR VGND sg13cmos5l_buf_1
Xfanout129 _1816_/B _3336_/Q VPWR VGND sg13cmos5l_buf_1
X_2653_ _2663_/A _2653_/A _2667_/B VPWR VGND sg13cmos5l_xnor2_1
X_2584_ _2592_/A _3292_/A _3292_/B VPWR VGND sg13cmos5l_nand2_1
XFILLER_27_227 VPWR VGND sg13cmos5l_decap_8
X_3205_ _3205_/Y _3202_/Y _3203_/Y _3204_/Y VPWR VGND sg13cmos5l_a21oi_1
X_3136_ _3136_/Y _3269_/D _3136_/B _3138_/C _3136_/D VPWR VGND sg13cmos5l_nor4_1
X_3067_ _3067_/Y _1933_/B _3145_/A _3053_/Y VPWR VGND sg13cmos5l_o21ai_1
X_2018_ _2018_/Y _2646_/A _1892_/Y _1896_/X _2085_/A VPWR VGND sg13cmos5l_a22oi_1
XFILLER_18_227 VPWR VGND sg13cmos5l_fill_1
XFILLER_26_282 VPWR VGND sg13cmos5l_decap_4
XFILLER_45_7 VPWR VGND sg13cmos5l_decap_8
XFILLER_20_403 VPWR VGND sg13cmos5l_fill_1
XFILLER_24_219 VPWR VGND sg13cmos5l_decap_8
X_2705_ _2705_/Y _2755_/A _2705_/B VPWR VGND sg13cmos5l_nor2_1
X_2636_ _2637_/B _2636_/A _2636_/B VPWR VGND sg13cmos5l_xor2_1
X_2567_ _2934_/B _2527_/Y _2566_/Y _2460_/A VPWR VGND sg13cmos5l_a21oi_1
X_2498_ _2500_/C _2498_/A _2498_/B _2498_/C _2510_/D VPWR VGND sg13cmos5l_nor4_1
X_3119_ _3119_/Y _3115_/A _3115_/B _3269_/A _2984_/A VPWR VGND sg13cmos5l_a22oi_1
XFILLER_11_403 VPWR VGND sg13cmos5l_fill_1
XFILLER_2_167 VPWR VGND sg13cmos5l_fill_2
XFILLER_0_59 VPWR VGND sg13cmos5l_fill_2
XFILLER_14_296 VPWR VGND sg13cmos5l_decap_4
X_2283_ _2293_/A _2315_/B _2315_/C _3054_/A VPWR VGND sg13cmos5l_a21oi_1
X_2421_ _2422_/C _2487_/A _2421_/B _2561_/A _2421_/D VPWR VGND sg13cmos5l_nor4_1
X_2352_ _2457_/C _2352_/A _2352_/B VPWR VGND sg13cmos5l_nor2_1
XFILLER_49_182 VPWR VGND sg13cmos5l_fill_2
XFILLER_20_266 VPWR VGND sg13cmos5l_fill_2
X_1998_ _3204_/B _1999_/B _2046_/C VPWR VGND sg13cmos5l_xnor2_1
X_2619_ _3334_/D _2617_/B _2671_/A2 _2618_/Y VPWR VGND sg13cmos5l_a21o_1
XFILLER_18_44 VPWR VGND sg13cmos5l_fill_1
XFILLER_28_377 VPWR VGND sg13cmos5l_fill_1
XFILLER_34_21 VPWR VGND sg13cmos5l_decap_4
XFILLER_11_233 VPWR VGND sg13cmos5l_fill_2
XFILLER_34_98 VPWR VGND sg13cmos5l_fill_2
XFILLER_19_311 VPWR VGND sg13cmos5l_fill_1
XFILLER_34_314 VPWR VGND sg13cmos5l_fill_2
XFILLER_46_185 VPWR VGND sg13cmos5l_fill_1
X_1852_ _1853_/B _1852_/A _1852_/B VPWR VGND sg13cmos5l_nand2_1
X_1921_ _2401_/A _2147_/A _2157_/B VPWR VGND sg13cmos5l_nor2_1
X_2970_ _2970_/Y _2963_/A _2984_/B _2967_/A VPWR VGND sg13cmos5l_a21oi_1
X_1783_ _1783_/X _2667_/A _1836_/A _1795_/A _1783_/D VPWR VGND sg13cmos5l_or4_1
X_3453_ _3453_/X _3453_/A VPWR VGND sg13cmos5l_buf_1
X_2266_ _2267_/D _2522_/B _2518_/A _2266_/C VPWR VGND sg13cmos5l_nand3_1
X_2335_ _2335_/Y _2318_/A _2326_/B _2091_/Y _3116_/A VPWR VGND sg13cmos5l_a22oi_1
X_3384_ _3384_/Q _3388_/CLK _3384_/D fanout170/X VPWR VGND sg13cmos5l_dfrbpq_1
X_2404_ _2405_/B _2404_/A _2500_/B _2549_/B VPWR VGND sg13cmos5l_nand3_1
XFILLER_37_196 VPWR VGND sg13cmos5l_decap_8
X_2197_ _2371_/B _2351_/A _2197_/B VPWR VGND sg13cmos5l_nor2_1
Xclkbuf_5_4__f_clk _3360_/CLK clkbuf_4_2_0_clk/X VPWR VGND sg13cmos5l_buf_8
XFILLER_28_130 VPWR VGND sg13cmos5l_fill_1
XFILLER_45_64 VPWR VGND sg13cmos5l_fill_1
XFILLER_45_86 VPWR VGND sg13cmos5l_decap_4
XFILLER_3_295 VPWR VGND sg13cmos5l_fill_2
X_2120_ _2467_/A _2433_/A _2280_/A VPWR VGND sg13cmos5l_nor2_1
XFILLER_34_133 VPWR VGND sg13cmos5l_decap_8
X_2051_ _2052_/B _3330_/Q _2051_/B _2068_/B _2051_/D VPWR VGND sg13cmos5l_nand4_1
XFILLER_15_391 VPWR VGND sg13cmos5l_fill_1
XFILLER_34_188 VPWR VGND sg13cmos5l_decap_8
X_1835_ _1835_/Y _1827_/Y _1937_/B _1834_/A _1874_/B VPWR VGND sg13cmos5l_a22oi_1
X_1904_ _1904_/Y _1874_/B _2006_/B _2023_/B _1804_/Y VPWR VGND sg13cmos5l_a22oi_1
X_2953_ _2953_/Y _2954_/B _2951_/Y VPWR VGND sg13cmos5l_nor2b_1
X_2884_ _2884_/Y _2885_/C _2925_/B _2884_/C VPWR VGND sg13cmos5l_nand3_1
X_1697_ _2932_/A _2929_/A VPWR VGND sg13cmos5l_inv_1
X_1766_ _1768_/D _1934_/A _1937_/A VPWR VGND sg13cmos5l_and2_1
X_2249_ _2280_/C _2249_/A _2059_/B VPWR VGND sg13cmos5l_nor2b_1
X_2318_ _2318_/Y _2318_/A _2326_/B VPWR VGND sg13cmos5l_nor2_1
X_3367_ _3367_/Q _3423_/CLK _3367_/D fanout178/X VPWR VGND sg13cmos5l_dfrbpq_1
X_3298_ _3298_/Q clkload2/A _3298_/D fanout176/X VPWR VGND sg13cmos5l_dfrbpq_1
XFILLER_40_114 VPWR VGND sg13cmos5l_decap_8
XFILLER_31_22 VPWR VGND sg13cmos5l_fill_2
XFILLER_31_88 VPWR VGND sg13cmos5l_decap_4
XFILLER_31_99 VPWR VGND sg13cmos5l_decap_8
XFILLER_40_169 VPWR VGND sg13cmos5l_decap_8
Xclkbuf_4_10_0_clk clkbuf_4_10_0_clk/X clkbuf_0_clk/X VPWR VGND sg13cmos5l_buf_8
XFILLER_48_203 VPWR VGND sg13cmos5l_fill_2
Xoutput9 uo_out[3] _3450_/X VPWR VGND sg13cmos5l_buf_1
Xoutput11 uo_out[5] _3452_/X VPWR VGND sg13cmos5l_buf_1
XFILLER_39_214 VPWR VGND sg13cmos5l_decap_8
XFILLER_39_236 VPWR VGND sg13cmos5l_fill_1
X_2103_ _2874_/B _3390_/Q _2867_/B _2873_/C _2103_/D VPWR VGND sg13cmos5l_nor4_1
X_3221_ _3221_/Y _3256_/A1 _1905_/B _2063_/B _3389_/Q _3220_/Y VPWR VGND sg13cmos5l_a221oi_1
X_3152_ _3152_/Y _3235_/A _3152_/B VPWR VGND sg13cmos5l_nor2_1
X_3083_ _3136_/B _3138_/A _3190_/A VPWR VGND sg13cmos5l_nand2_1
X_2034_ _2034_/Y _2667_/A _3303_/Q _2077_/A VPWR VGND sg13cmos5l_o21ai_1
X_1818_ _1818_/X _3050_/B _3304_/Q _2322_/A VPWR VGND sg13cmos5l_and3_1
Xhold310 _2893_/A _3400_/Q VPWR VGND sg13cmos5l_dlygate4sd3_1
X_2936_ _2936_/Y _3098_/A _2952_/A _3101_/B VPWR VGND sg13cmos5l_nor3_1
X_2867_ _2871_/C _3390_/Q _2867_/B _2892_/B VPWR VGND sg13cmos5l_nor3_1
X_2798_ _2798_/Y _2812_/A _2798_/B _2798_/C VPWR VGND sg13cmos5l_nor3_1
X_1749_ _2544_/A _2351_/A _2351_/B VPWR VGND sg13cmos5l_nor2_1
Xhold376 hold376/X _3357_/Q VPWR VGND sg13cmos5l_dlygate4sd3_1
Xhold365 hold365/X _3387_/Q VPWR VGND sg13cmos5l_dlygate4sd3_1
Xhold354 hold354/X _3338_/Q VPWR VGND sg13cmos5l_dlygate4sd3_1
Xhold343 _2947_/A _3296_/Q VPWR VGND sg13cmos5l_dlygate4sd3_1
Xhold332 _3279_/B _3324_/Q VPWR VGND sg13cmos5l_dlygate4sd3_1
Xhold321 hold321/X _3307_/Q VPWR VGND sg13cmos5l_dlygate4sd3_1
X_3419_ _3419_/Q _3419_/CLK _3419_/D fanout172/X VPWR VGND sg13cmos5l_dfrbpq_1
XFILLER_45_228 VPWR VGND sg13cmos5l_fill_1
XFILLER_42_21 VPWR VGND sg13cmos5l_decap_8
XFILLER_42_32 VPWR VGND sg13cmos5l_fill_1
XFILLER_42_76 VPWR VGND sg13cmos5l_fill_1
XFILLER_21_191 VPWR VGND sg13cmos5l_fill_2
XFILLER_29_291 VPWR VGND sg13cmos5l_fill_2
X_2721_ _2721_/Y _1678_/Y _2767_/B _2713_/Y _2720_/X VPWR VGND sg13cmos5l_a22oi_1
X_2652_ _2658_/A _2653_/A _2667_/B VPWR VGND sg13cmos5l_nand2_1
Xfanout108 _2769_/A hold368/X VPWR VGND sg13cmos5l_buf_1
Xfanout119 _1937_/A _2031_/B2 VPWR VGND sg13cmos5l_buf_1
X_3204_ _3204_/Y _3204_/A _3204_/B VPWR VGND sg13cmos5l_nor2_1
X_2583_ _3292_/B _3288_/A _2574_/B _2582_/Y VPWR VGND sg13cmos5l_a21o_1
X_2017_ _2017_/Y _2646_/A _1892_/Y _2027_/C VPWR VGND sg13cmos5l_o21ai_1
X_3135_ _3136_/D _3144_/A _3138_/B _3134_/Y VPWR VGND sg13cmos5l_o21ai_1
X_3066_ _3066_/Y _3066_/A _3091_/A VPWR VGND sg13cmos5l_nor2_1
XFILLER_10_117 VPWR VGND sg13cmos5l_fill_1
X_2919_ _2919_/Y _2919_/A _2925_/B _2923_/C VPWR VGND sg13cmos5l_nand3_1
XFILLER_26_272 VPWR VGND sg13cmos5l_fill_2
XFILLER_37_43 VPWR VGND sg13cmos5l_decap_8
XFILLER_38_7 VPWR VGND sg13cmos5l_decap_8
XFILLER_5_143 VPWR VGND sg13cmos5l_fill_1
XFILLER_5_154 VPWR VGND sg13cmos5l_fill_2
XFILLER_17_250 VPWR VGND sg13cmos5l_fill_2
X_2704_ _2704_/Y _1688_/Y _2757_/A2 _2703_/Y _2678_/Y VPWR VGND sg13cmos5l_a22oi_1
X_2635_ _2636_/B _2635_/A _2634_/Y VPWR VGND sg13cmos5l_nor2b_1
X_2566_ _2566_/Y _2568_/S _2565_/Y _2564_/Y VPWR VGND sg13cmos5l_a21oi_1
X_2497_ _2510_/D _2540_/B _2497_/B VPWR VGND sg13cmos5l_nand2_1
X_3118_ _3118_/Y _3301_/Q _3091_/A _3116_/Y _3117_/Y VPWR VGND sg13cmos5l_a22oi_1
X_3049_ _3049_/Y _3181_/B _3049_/B _3304_/Q VPWR VGND sg13cmos5l_nand3b_1
XFILLER_48_64 VPWR VGND sg13cmos5l_fill_1
XFILLER_48_86 VPWR VGND sg13cmos5l_decap_4
XFILLER_14_220 VPWR VGND sg13cmos5l_decap_4
XFILLER_14_275 VPWR VGND sg13cmos5l_decap_8
XFILLER_9_58 VPWR VGND sg13cmos5l_fill_1
Xfanout90 _3254_/A _3378_/Q VPWR VGND sg13cmos5l_buf_1
X_2420_ _2421_/D _2431_/B _2420_/B VPWR VGND sg13cmos5l_nand2b_1
X_2282_ _2282_/X _3066_/A _2337_/B VPWR VGND sg13cmos5l_and2_1
X_2351_ _2461_/B _2351_/A _2351_/B _2351_/C _2351_/D VPWR VGND sg13cmos5l_nor4_1
XFILLER_49_194 VPWR VGND sg13cmos5l_fill_1
X_1997_ _2068_/B _1999_/B _2046_/C VPWR VGND sg13cmos5l_nand2_1
X_2618_ _2618_/Y _2623_/A _2617_/Y _3293_/A VPWR VGND sg13cmos5l_a21oi_1
X_2549_ _2550_/D _2549_/A _2549_/B _2549_/C _2553_/D VPWR VGND sg13cmos5l_and4_1
XFILLER_28_345 VPWR VGND sg13cmos5l_fill_1
XFILLER_11_212 VPWR VGND sg13cmos5l_decap_8
XFILLER_34_55 VPWR VGND sg13cmos5l_fill_2
XFILLER_34_77 VPWR VGND sg13cmos5l_decap_8
X_1851_ _1852_/B _2076_/A _1941_/B VPWR VGND sg13cmos5l_nand2_1
X_1920_ _2157_/B _3421_/Q _3422_/Q VPWR VGND sg13cmos5l_nand2b_1
X_1782_ _1783_/D _2633_/A _2289_/C _1777_/Y VPWR VGND sg13cmos5l_o21ai_1
X_3452_ _3452_/X _3452_/A VPWR VGND sg13cmos5l_buf_1
X_3383_ _3383_/Q _3383_/CLK _3383_/D fanout170/X VPWR VGND sg13cmos5l_dfrbpq_1
X_2403_ _2549_/B _2265_/A _2238_/D _2265_/B VPWR VGND sg13cmos5l_o21ai_1
XFILLER_27_0 VPWR VGND sg13cmos5l_fill_1
X_2196_ _2520_/C _2196_/A _2436_/B VPWR VGND sg13cmos5l_nor2_1
X_2265_ _2266_/C _2265_/A _2265_/B VPWR VGND sg13cmos5l_nand2_1
X_2334_ _2334_/Y _2320_/Y _2323_/Y _2317_/A VPWR VGND sg13cmos5l_o21ai_1
XFILLER_25_304 VPWR VGND sg13cmos5l_fill_2
XFILLER_37_153 VPWR VGND sg13cmos5l_decap_4
XFILLER_29_33 VPWR VGND sg13cmos5l_fill_1
XFILLER_16_326 VPWR VGND sg13cmos5l_decap_4
XFILLER_29_77 VPWR VGND sg13cmos5l_fill_1
XFILLER_43_123 VPWR VGND sg13cmos5l_decap_8
XFILLER_45_32 VPWR VGND sg13cmos5l_decap_4
XFILLER_45_98 VPWR VGND sg13cmos5l_decap_4
X_2050_ _3208_/B _2064_/A _2060_/D VPWR VGND sg13cmos5l_xnor2_1
XFILLER_15_370 VPWR VGND sg13cmos5l_decap_8
XFILLER_34_123 VPWR VGND sg13cmos5l_fill_1
X_2952_ _2954_/B _2952_/A _2963_/B VPWR VGND sg13cmos5l_xnor2_1
XFILLER_30_340 VPWR VGND sg13cmos5l_fill_2
X_1765_ _1765_/Y _2084_/A _1862_/B VPWR VGND sg13cmos5l_xnor2_1
X_1834_ _1836_/B _1834_/A VPWR VGND sg13cmos5l_inv_1
X_1903_ _2023_/B _2984_/A _1903_/B VPWR VGND sg13cmos5l_xnor2_1
X_2883_ _2883_/Y _1694_/Y _2880_/Y _2884_/C VPWR VGND sg13cmos5l_o21ai_1
X_1696_ _2902_/A _2908_/A VPWR VGND sg13cmos5l_inv_1
X_3366_ _3366_/Q clkload4/A _3366_/D fanout172/X VPWR VGND sg13cmos5l_dfrbpq_1
X_2179_ _2522_/B _2206_/A _2179_/B VPWR VGND sg13cmos5l_nand2_1
X_2248_ _2551_/A _2248_/A _2248_/B _2363_/A VPWR VGND sg13cmos5l_and3_1
X_2317_ _2317_/X _2317_/A _2317_/B VPWR VGND sg13cmos5l_and2_1
X_3297_ _3297_/Q _3373_/CLK _3297_/D fanout175/X VPWR VGND sg13cmos5l_dfrbpq_1
XFILLER_40_104 VPWR VGND sg13cmos5l_decap_4
XFILLER_40_137 VPWR VGND sg13cmos5l_fill_1
XFILLER_31_78 VPWR VGND sg13cmos5l_fill_2
Xoutput12 uo_out[6] _3453_/X VPWR VGND sg13cmos5l_buf_1
XFILLER_16_145 VPWR VGND sg13cmos5l_decap_8
XFILLER_16_156 VPWR VGND sg13cmos5l_fill_2
XFILLER_12_362 VPWR VGND sg13cmos5l_decap_8
XFILLER_12_373 VPWR VGND sg13cmos5l_fill_1
XFILLER_31_137 VPWR VGND sg13cmos5l_decap_8
X_3220_ _3220_/Y _3256_/A1 _2092_/B _3219_/Y VPWR VGND sg13cmos5l_o21ai_1
X_2033_ _2033_/Y _2667_/A _3303_/Q _2030_/Y _2031_/Y _2032_/Y VPWR VGND sg13cmos5l_a221oi_1
X_2102_ _2239_/A _2407_/A _2520_/B VPWR VGND sg13cmos5l_and2_1
X_3151_ _3152_/B _3351_/Q _3166_/B _3167_/C _3150_/Y VPWR VGND sg13cmos5l_a22oi_1
X_3082_ _3127_/A _3064_/Y _3082_/B _3082_/C VPWR VGND sg13cmos5l_nand3b_1
XFILLER_22_159 VPWR VGND sg13cmos5l_fill_2
X_2935_ _2942_/A _3274_/B _2939_/A _2935_/C VPWR VGND sg13cmos5l_nand3_1
XFILLER_30_170 VPWR VGND sg13cmos5l_decap_8
X_1748_ _2351_/B _2134_/B _2214_/B VPWR VGND sg13cmos5l_nand2_1
X_1817_ _1817_/X _1865_/B _1865_/C VPWR VGND sg13cmos5l_and2_1
Xhold344 _2949_/A _2948_/Y VPWR VGND sg13cmos5l_dlygate4sd3_1
Xhold333 _3324_/D _3281_/X VPWR VGND sg13cmos5l_dlygate4sd3_1
Xhold322 _3018_/A _3017_/Y VPWR VGND sg13cmos5l_dlygate4sd3_1
Xhold311 _2894_/C _2893_/Y VPWR VGND sg13cmos5l_dlygate4sd3_1
Xhold300 _2867_/B _3391_/Q VPWR VGND sg13cmos5l_dlygate4sd3_1
X_2866_ _2866_/Y _2865_/A _2892_/B _2865_/Y VPWR VGND sg13cmos5l_o21ai_1
X_2797_ _2798_/C _3269_/B _3269_/C VPWR VGND sg13cmos5l_and2_1
X_1679_ _2755_/A _3360_/Q VPWR VGND sg13cmos5l_inv_1
Xhold377 hold377/X _3301_/Q VPWR VGND sg13cmos5l_dlygate4sd3_1
Xhold366 hold366/X _3379_/Q VPWR VGND sg13cmos5l_dlygate4sd3_1
Xhold355 hold355/X _3306_/Q VPWR VGND sg13cmos5l_dlygate4sd3_1
X_3418_ _3418_/Q clkload4/A _3418_/D fanout172/X VPWR VGND sg13cmos5l_dfrbpq_1
X_3349_ _3349_/Q _3349_/CLK _3349_/D fanout165/X VPWR VGND sg13cmos5l_dfrbpq_1
XFILLER_5_314 VPWR VGND sg13cmos5l_fill_2
XFILLER_36_218 VPWR VGND sg13cmos5l_decap_8
X_2720_ _2720_/X _2728_/A _2740_/A _2736_/B _2720_/D VPWR VGND sg13cmos5l_or4_1
X_2651_ _2666_/A _2084_/A _3338_/Q _2646_/B VPWR VGND sg13cmos5l_o21ai_1
X_2582_ _2582_/Y _1972_/A _3288_/B _2581_/A _3286_/B VPWR VGND sg13cmos5l_a22oi_1
Xfanout109 _2738_/B _3364_/Q VPWR VGND sg13cmos5l_buf_1
X_3203_ _3203_/Y _3204_/A _3204_/B _2067_/B _3382_/Q VPWR VGND sg13cmos5l_a22oi_1
X_2016_ _2027_/C _2016_/A _2029_/A _2028_/C VPWR VGND sg13cmos5l_nand3_1
X_3134_ _3134_/Y _3138_/B _3144_/C VPWR VGND sg13cmos5l_nand2_1
X_3065_ _3065_/Y _3065_/A _3115_/B VPWR VGND sg13cmos5l_nor2_1
X_2918_ _2918_/Y _2918_/A _2923_/C VPWR VGND sg13cmos5l_nand2_1
X_2849_ _2852_/C _2849_/A _3159_/A VPWR VGND sg13cmos5l_nand2_1
XFILLER_37_11 VPWR VGND sg13cmos5l_fill_1
XFILLER_37_22 VPWR VGND sg13cmos5l_decap_8
XFILLER_37_66 VPWR VGND sg13cmos5l_fill_1
XFILLER_14_402 VPWR VGND sg13cmos5l_fill_2
XFILLER_5_122 VPWR VGND sg13cmos5l_fill_2
XFILLER_5_166 VPWR VGND sg13cmos5l_fill_2
XFILLER_32_221 VPWR VGND sg13cmos5l_decap_4
X_2703_ _2703_/Y _2751_/A _2703_/B _2703_/C VPWR VGND sg13cmos5l_nand3_1
X_2634_ _2634_/Y _2634_/A _2673_/B VPWR VGND sg13cmos5l_nand2_1
X_2565_ _2565_/Y _2565_/A _2565_/B VPWR VGND sg13cmos5l_nand2_1
X_3117_ _3117_/Y _2971_/A _3138_/A _3103_/Y _3107_/X _3106_/B VPWR VGND sg13cmos5l_a221oi_1
X_2496_ _2498_/C _2496_/A _2496_/B VPWR VGND sg13cmos5l_nand2_1
XFILLER_23_232 VPWR VGND sg13cmos5l_fill_1
XFILLER_23_243 VPWR VGND sg13cmos5l_decap_8
XFILLER_23_265 VPWR VGND sg13cmos5l_decap_8
X_3048_ _3049_/B _3048_/A _3048_/B VPWR VGND sg13cmos5l_nand2_1
XFILLER_2_147 VPWR VGND sg13cmos5l_fill_1
XFILLER_48_21 VPWR VGND sg13cmos5l_decap_8
Xfanout80 _3124_/A hold347/X VPWR VGND sg13cmos5l_buf_1
Xfanout91 _3089_/A _3253_/A1 VPWR VGND sg13cmos5l_buf_1
XFILLER_49_184 VPWR VGND sg13cmos5l_fill_1
X_2281_ _2302_/C _3046_/A _3254_/B _2092_/B VPWR VGND sg13cmos5l_o21ai_1
X_2350_ _3422_/D _2539_/A _2503_/A _2350_/C VPWR VGND sg13cmos5l_nand3_1
XFILLER_37_357 VPWR VGND sg13cmos5l_fill_1
XFILLER_20_224 VPWR VGND sg13cmos5l_decap_8
X_1996_ _2046_/C _3325_/Q _3324_/Q _2037_/A VPWR VGND sg13cmos5l_a21o_1
X_2617_ _2617_/Y _3295_/Q _2617_/B VPWR VGND sg13cmos5l_nand2b_1
X_2548_ _2553_/D _2369_/A _2179_/B _2240_/A VPWR VGND sg13cmos5l_o21ai_1
X_2479_ _2480_/D _2774_/A _2542_/A _2479_/C VPWR VGND sg13cmos5l_nand3_1
Xclkload0 clkload0/Y clkload0/A VPWR VGND sg13cmos5l_inv_1
XFILLER_19_302 VPWR VGND sg13cmos5l_decap_8
Xclkbuf_5_29__f_clk _3412_/CLK clkbuf_4_14_0_clk/X VPWR VGND sg13cmos5l_buf_8
XFILLER_46_165 VPWR VGND sg13cmos5l_fill_2
X_1781_ _1866_/B _2007_/A _1781_/B VPWR VGND sg13cmos5l_xnor2_1
X_1850_ _1955_/A _2076_/A _1941_/B VPWR VGND sg13cmos5l_and2_1
X_2333_ _2333_/X _2329_/Y _2330_/Y _2332_/Y VPWR VGND sg13cmos5l_a21o_1
X_3451_ _3451_/X _3451_/A VPWR VGND sg13cmos5l_buf_1
X_3382_ _3382_/Q clkload3/A _3382_/D fanout171/X VPWR VGND sg13cmos5l_dfrbpq_1
X_2402_ _2503_/B _2562_/C _2402_/B VPWR VGND sg13cmos5l_nand2b_1
X_2195_ _2443_/B _2435_/B _2195_/B VPWR VGND sg13cmos5l_nor2_1
X_2264_ _2361_/B _2512_/B _2556_/A VPWR VGND sg13cmos5l_nand2b_1
XFILLER_25_349 VPWR VGND sg13cmos5l_fill_2
XFILLER_37_187 VPWR VGND sg13cmos5l_decap_4
X_1979_ _1980_/D _1978_/Y _1988_/B _1979_/S VPWR VGND sg13cmos5l_mux2_1
XFILLER_28_110 VPWR VGND sg13cmos5l_decap_8
XFILLER_28_176 VPWR VGND sg13cmos5l_decap_4
XFILLER_43_157 VPWR VGND sg13cmos5l_fill_2
XFILLER_45_55 VPWR VGND sg13cmos5l_fill_2
XFILLER_3_231 VPWR VGND sg13cmos5l_fill_2
XFILLER_6_38 VPWR VGND sg13cmos5l_fill_1
X_1902_ _1902_/Y _1893_/Y _1898_/Y _1901_/Y VPWR VGND sg13cmos5l_o21ai_1
X_2951_ _2951_/Y _3100_/A _2947_/B _2945_/Y VPWR VGND sg13cmos5l_o21ai_1
X_1764_ _1889_/B _2646_/A _1862_/B VPWR VGND sg13cmos5l_xnor2_1
X_1833_ _1834_/A _2302_/A _2302_/B VPWR VGND sg13cmos5l_xnor2_1
X_2882_ _2884_/C _2882_/A _2882_/B VPWR VGND sg13cmos5l_nand2_1
X_1695_ _1695_/Y _2889_/B VPWR VGND sg13cmos5l_inv_1
X_2316_ _2317_/B _2315_/B _2315_/C _2315_/A VPWR VGND sg13cmos5l_a21o_1
Xclkbuf_5_12__f_clk _3349_/CLK clkbuf_4_6_0_clk/X VPWR VGND sg13cmos5l_buf_8
X_3365_ _3365_/Q _3365_/CLK _3365_/D fanout163/X VPWR VGND sg13cmos5l_dfrbpq_1
X_3296_ _3296_/Q clkload2/A _3296_/D fanout175/X VPWR VGND sg13cmos5l_dfrbpq_1
X_2178_ _2195_/B _2178_/A _2178_/B VPWR VGND sg13cmos5l_nand2_1
X_2247_ _2425_/B _2522_/C _2358_/B VPWR VGND sg13cmos5l_or2_1
XFILLER_21_363 VPWR VGND sg13cmos5l_decap_4
XFILLER_31_35 VPWR VGND sg13cmos5l_decap_4
XFILLER_0_212 VPWR VGND sg13cmos5l_fill_2
Xoutput13 uo_out[7] _3454_/X VPWR VGND sg13cmos5l_buf_1
XFILLER_8_356 VPWR VGND sg13cmos5l_fill_2
X_3150_ _3150_/Y _3150_/A _3171_/D VPWR VGND sg13cmos5l_nor2_1
X_2032_ _2032_/Y _2032_/A _2941_/B VPWR VGND sg13cmos5l_nor2_1
X_2101_ _2520_/B _2197_/B _2270_/A VPWR VGND sg13cmos5l_nor2_1
X_3081_ _3082_/C _3272_/A _1941_/B _3045_/Y _3071_/Y VPWR VGND sg13cmos5l_a22oi_1
XFILLER_15_190 VPWR VGND sg13cmos5l_decap_4
XFILLER_22_105 VPWR VGND sg13cmos5l_decap_4
X_2934_ _3295_/D _2934_/A _2934_/B _2934_/C VPWR VGND sg13cmos5l_nand3_1
X_2865_ _2865_/Y _2865_/A _2873_/D VPWR VGND sg13cmos5l_nand2_1
X_1678_ _1678_/Y _1678_/A VPWR VGND sg13cmos5l_inv_1
X_1747_ _2216_/A _2147_/A _2213_/B VPWR VGND sg13cmos5l_nor2_1
X_1816_ _1865_/C _1816_/A _1816_/B _3181_/A VPWR VGND sg13cmos5l_nand3_1
Xhold378 hold378/X _3388_/Q VPWR VGND sg13cmos5l_dlygate4sd3_1
Xhold367 _2043_/B _3322_/Q VPWR VGND sg13cmos5l_dlygate4sd3_1
Xhold356 hold356/X _3363_/Q VPWR VGND sg13cmos5l_dlygate4sd3_1
Xhold345 hold345/X _3377_/Q VPWR VGND sg13cmos5l_dlygate4sd3_1
Xhold334 _2680_/A _3358_/Q VPWR VGND sg13cmos5l_dlygate4sd3_1
Xhold323 hold323/X _3406_/Q VPWR VGND sg13cmos5l_dlygate4sd3_1
Xhold312 _3400_/D _2894_/Y VPWR VGND sg13cmos5l_dlygate4sd3_1
Xhold301 _2870_/B _2869_/Y VPWR VGND sg13cmos5l_dlygate4sd3_1
X_2796_ _3370_/D _3269_/C _2806_/A _2795_/Y VPWR VGND sg13cmos5l_a21o_1
X_3417_ _3417_/Q clkload1/A _3417_/D fanout167/X VPWR VGND sg13cmos5l_dfrbpq_1
X_3348_ _3348_/Q _3349_/CLK _3348_/D fanout168/X VPWR VGND sg13cmos5l_dfrbpq_1
X_3279_ _3279_/Y _3295_/Q _3279_/B VPWR VGND sg13cmos5l_nand2b_1
XFILLER_21_182 VPWR VGND sg13cmos5l_decap_4
XFILLER_42_45 VPWR VGND sg13cmos5l_decap_4
XFILLER_3_39 VPWR VGND sg13cmos5l_fill_2
XFILLER_4_370 VPWR VGND sg13cmos5l_fill_2
X_2650_ _2655_/A _2664_/A _2664_/B VPWR VGND sg13cmos5l_nand2_1
X_2581_ _3289_/A _2581_/A _3286_/B VPWR VGND sg13cmos5l_nand2_1
X_3202_ _3202_/Y _3121_/A _2067_/B _3201_/Y VPWR VGND sg13cmos5l_o21ai_1
X_3133_ _3133_/Y _3353_/Q _3171_/B _3171_/C _3171_/D VPWR VGND sg13cmos5l_nand4_1
X_2015_ _2028_/C _2084_/A _3105_/A VPWR VGND sg13cmos5l_nand2b_1
X_3064_ _3064_/Y _3045_/Y _3047_/Y _3059_/Y _3063_/Y VPWR VGND sg13cmos5l_a22oi_1
X_2917_ _2923_/C _2917_/A _2917_/B VPWR VGND sg13cmos5l_or2_1
X_2848_ _3159_/A _3164_/D _3124_/A VPWR VGND sg13cmos5l_and2_1
X_2779_ _2779_/Y _3313_/D _1735_/Y _1738_/X VPWR VGND sg13cmos5l_a21oi_1
XFILLER_37_78 VPWR VGND sg13cmos5l_decap_8
XFILLER_37_89 VPWR VGND sg13cmos5l_fill_2
XFILLER_1_362 VPWR VGND sg13cmos5l_fill_1
XFILLER_17_252 VPWR VGND sg13cmos5l_fill_1
XFILLER_32_200 VPWR VGND sg13cmos5l_fill_1
X_2702_ _2703_/C _3360_/Q _2697_/B _2701_/Y VPWR VGND sg13cmos5l_a21oi_1
X_2633_ _2635_/A _2633_/A _2673_/B VPWR VGND sg13cmos5l_nor2_1
X_2564_ _2564_/Y _2564_/A _2564_/B _2564_/C VPWR VGND sg13cmos5l_nand3_1
X_2495_ _2496_/B input4/X _2269_/B _2269_/C VPWR VGND sg13cmos5l_o21ai_1
X_3116_ _3116_/Y _3116_/A _3145_/B _3116_/C VPWR VGND sg13cmos5l_nand3_1
XFILLER_23_277 VPWR VGND sg13cmos5l_decap_8
X_3047_ _3047_/Y _2302_/A _2302_/B _3046_/Y VPWR VGND sg13cmos5l_o21ai_1
XFILLER_48_99 VPWR VGND sg13cmos5l_decap_8
Xfanout70 _2240_/A _1715_/Y VPWR VGND sg13cmos5l_buf_1
Xfanout81 _3165_/A hold361/X VPWR VGND sg13cmos5l_buf_1
Xfanout92 _3253_/A1 hold345/X VPWR VGND sg13cmos5l_buf_1
XFILLER_49_141 VPWR VGND sg13cmos5l_decap_4
XFILLER_49_163 VPWR VGND sg13cmos5l_fill_2
X_2280_ _2514_/A _2280_/A _2435_/B _2280_/C VPWR VGND sg13cmos5l_nor3_1
X_1995_ _2278_/B _2041_/A _2040_/B _2446_/B VPWR VGND sg13cmos5l_a21oi_1
X_2616_ _2623_/A _3181_/A _3295_/Q VPWR VGND sg13cmos5l_nand2b_1
X_2547_ _2550_/C _2547_/A _2547_/B _2547_/C _2547_/D VPWR VGND sg13cmos5l_and4_1
X_2478_ _2479_/C _2206_/A _2412_/B _2499_/A VPWR VGND sg13cmos5l_a21oi_1
XFILLER_28_303 VPWR VGND sg13cmos5l_decap_8
XFILLER_34_35 VPWR VGND sg13cmos5l_decap_8
Xclkload1 clkload1/Y clkload1/A VPWR VGND sg13cmos5l_inv_1
XFILLER_3_402 VPWR VGND sg13cmos5l_fill_2
XFILLER_46_133 VPWR VGND sg13cmos5l_fill_2
X_1780_ _1780_/X _1862_/B _1862_/C VPWR VGND sg13cmos5l_or2_1
X_2332_ _2332_/Y _1886_/B _2077_/Y _2331_/Y VPWR VGND sg13cmos5l_o21ai_1
X_3450_ _3450_/X _3450_/A VPWR VGND sg13cmos5l_buf_1
X_3381_ _3381_/Q clkload3/A _3381_/D fanout170/X VPWR VGND sg13cmos5l_dfrbpq_1
X_2401_ _2562_/C _2401_/A _2401_/B _2401_/C VPWR VGND sg13cmos5l_nand3_1
XFILLER_37_166 VPWR VGND sg13cmos5l_decap_8
X_2194_ _2524_/A _2436_/A _2435_/B VPWR VGND sg13cmos5l_nor2_1
X_2263_ _2556_/A _2265_/A _2136_/Y _2240_/A VPWR VGND sg13cmos5l_o21ai_1
XFILLER_18_391 VPWR VGND sg13cmos5l_fill_2
X_1978_ _1978_/Y _2244_/A _1988_/B _2573_/A VPWR VGND sg13cmos5l_nand3b_1
XFILLER_29_68 VPWR VGND sg13cmos5l_fill_1
XFILLER_16_306 VPWR VGND sg13cmos5l_fill_1
XFILLER_43_103 VPWR VGND sg13cmos5l_decap_8
XFILLER_43_114 VPWR VGND sg13cmos5l_decap_4
XFILLER_43_147 VPWR VGND sg13cmos5l_decap_4
XFILLER_19_144 VPWR VGND sg13cmos5l_fill_2
XFILLER_19_155 VPWR VGND sg13cmos5l_decap_4
XFILLER_15_350 VPWR VGND sg13cmos5l_fill_1
XFILLER_42_191 VPWR VGND sg13cmos5l_decap_8
X_1832_ _1832_/Y _1811_/Y _1825_/Y _1831_/Y VPWR VGND sg13cmos5l_o21ai_1
X_1901_ _1901_/Y _3180_/B _1896_/X _1899_/Y _1836_/A VPWR VGND sg13cmos5l_a22oi_1
X_2950_ _2950_/Y _2952_/A _2950_/B VPWR VGND sg13cmos5l_nand2_1
X_2881_ _2881_/X _2885_/A _2885_/D _2880_/Y VPWR VGND sg13cmos5l_a21o_1
XFILLER_30_386 VPWR VGND sg13cmos5l_fill_2
X_1694_ _1694_/Y _2885_/B VPWR VGND sg13cmos5l_inv_1
X_1763_ _1826_/B _2084_/A _2007_/A _2028_/A _1865_/B VPWR VGND sg13cmos5l_nand4_1
XFILLER_32_0 VPWR VGND sg13cmos5l_fill_2
X_2246_ _2358_/B _2351_/C _2246_/B VPWR VGND sg13cmos5l_nor2_1
X_2315_ _2317_/A _2315_/A _2315_/B _2315_/C VPWR VGND sg13cmos5l_nand3_1
X_3364_ _3364_/Q _3364_/CLK _3364_/D fanout163/X VPWR VGND sg13cmos5l_dfrbpq_1
X_3295_ _3295_/Q clkload1/A _3295_/D fanout166/X VPWR VGND sg13cmos5l_dfrbpq_1
XFILLER_25_103 VPWR VGND sg13cmos5l_fill_2
XFILLER_25_125 VPWR VGND sg13cmos5l_decap_8
X_2177_ _2179_/B _2178_/A _2178_/B VPWR VGND sg13cmos5l_and2_1
XFILLER_40_128 VPWR VGND sg13cmos5l_decap_8
XFILLER_16_136 VPWR VGND sg13cmos5l_fill_1
XFILLER_16_169 VPWR VGND sg13cmos5l_fill_1
XFILLER_31_106 VPWR VGND sg13cmos5l_fill_1
XFILLER_12_386 VPWR VGND sg13cmos5l_decap_4
XFILLER_12_397 VPWR VGND sg13cmos5l_decap_8
X_2100_ _2270_/A _3425_/Q _2139_/B VPWR VGND sg13cmos5l_nand2_1
X_3080_ _3082_/B _3175_/A _3174_/B _3080_/C VPWR VGND sg13cmos5l_nor3_1
X_2031_ _2031_/Y _2032_/A _2941_/B _2971_/A _2031_/B2 VPWR VGND sg13cmos5l_a22oi_1
XFILLER_22_128 VPWR VGND sg13cmos5l_decap_4
X_1815_ _1815_/X _3304_/Q _2322_/A _3050_/B VPWR VGND sg13cmos5l_a21o_1
X_2933_ _2934_/C hold363/X _2570_/A _3276_/B VPWR VGND sg13cmos5l_o21ai_1
X_2864_ _2873_/D _2874_/A _2874_/C _2932_/B VPWR VGND sg13cmos5l_a21oi_1
X_2795_ _2795_/Y _3269_/C _2812_/A _2805_/B VPWR VGND sg13cmos5l_nor3_1
XFILLER_7_82 VPWR VGND sg13cmos5l_fill_1
X_1677_ _2002_/A _3331_/Q VPWR VGND sg13cmos5l_inv_1
X_1746_ _2213_/B _3422_/Q _3421_/Q VPWR VGND sg13cmos5l_nand2b_1
Xhold379 hold379/X _3303_/Q VPWR VGND sg13cmos5l_dlygate4sd3_1
Xhold368 hold368/X _3364_/Q VPWR VGND sg13cmos5l_dlygate4sd3_1
Xhold357 hold357/X _3335_/Q VPWR VGND sg13cmos5l_dlygate4sd3_1
Xhold346 _3377_/D _2822_/Y VPWR VGND sg13cmos5l_dlygate4sd3_1
Xhold335 hold335/X _3360_/Q VPWR VGND sg13cmos5l_dlygate4sd3_1
Xhold324 _2835_/A _3380_/Q VPWR VGND sg13cmos5l_dlygate4sd3_1
Xhold313 _2865_/A _3390_/Q VPWR VGND sg13cmos5l_dlygate4sd3_1
Xhold302 _3391_/D _2870_/Y VPWR VGND sg13cmos5l_dlygate4sd3_1
X_3416_ _3416_/Q _3416_/CLK _3416_/D fanout167/X VPWR VGND sg13cmos5l_dfrbpq_1
X_2229_ _2352_/A _2248_/A _2250_/A VPWR VGND sg13cmos5l_nand2_1
X_3347_ _3347_/Q _3365_/CLK _3347_/D fanout164/X VPWR VGND sg13cmos5l_dfrbpq_1
X_3278_ _3323_/D _3278_/A VPWR VGND sg13cmos5l_inv_1
XFILLER_5_327 VPWR VGND sg13cmos5l_fill_1
XFILLER_44_264 VPWR VGND sg13cmos5l_fill_1
XFILLER_12_183 VPWR VGND sg13cmos5l_fill_1
XFILLER_12_194 VPWR VGND sg13cmos5l_fill_1
X_2580_ _3286_/B _3285_/A _3285_/B VPWR VGND sg13cmos5l_nand2_1
X_3201_ _3201_/Y _1977_/B _3200_/Y _3199_/Y VPWR VGND sg13cmos5l_o21ai_1
X_3132_ _3167_/B _3171_/C _3130_/Y _3129_/Y VPWR VGND sg13cmos5l_a21o_1
X_3063_ _3063_/Y _3253_/A1 _1834_/A _3062_/Y VPWR VGND sg13cmos5l_o21ai_1
X_2014_ _2029_/A _3105_/A _2084_/A VPWR VGND sg13cmos5l_nand2b_1
X_2916_ _2916_/Y _2917_/A _2925_/B _2917_/B VPWR VGND sg13cmos5l_nand3_1
X_2847_ _3385_/D _2860_/A _2847_/B _2850_/B VPWR VGND sg13cmos5l_nor3_1
X_2778_ _3141_/B _3121_/A _3168_/C _3199_/A VPWR VGND sg13cmos5l_nand3_1
X_1729_ _1736_/D _3419_/D _3416_/D VPWR VGND sg13cmos5l_nor2_1
XFILLER_26_220 VPWR VGND sg13cmos5l_decap_4
XFILLER_26_286 VPWR VGND sg13cmos5l_fill_1
XFILLER_17_220 VPWR VGND sg13cmos5l_fill_1
XFILLER_17_275 VPWR VGND sg13cmos5l_fill_2
XFILLER_32_289 VPWR VGND sg13cmos5l_fill_2
X_2701_ _2701_/Y _3357_/Q _2691_/B VPWR VGND sg13cmos5l_nor2b_1
X_2632_ _2636_/A _2626_/X _2628_/X _2627_/X VPWR VGND sg13cmos5l_a21oi_1
X_2563_ _2564_/C _2563_/A _3274_/C _2563_/C _2563_/D VPWR VGND sg13cmos5l_nand4_1
X_2494_ _2501_/B _2939_/A _2494_/B _2494_/C VPWR VGND sg13cmos5l_nand3_1
X_3115_ _3115_/Y _3115_/A _3115_/B VPWR VGND sg13cmos5l_nor2_1
X_3046_ _3046_/Y _3046_/A _3269_/A VPWR VGND sg13cmos5l_nand2_1
XFILLER_14_289 VPWR VGND sg13cmos5l_decap_8
Xfanout60 _2450_/A _1741_/X VPWR VGND sg13cmos5l_buf_1
Xfanout71 _2446_/A _1715_/Y VPWR VGND sg13cmos5l_buf_1
Xfanout82 _3229_/A _3384_/Q VPWR VGND sg13cmos5l_buf_1
Xfanout93 _3138_/A _3376_/Q VPWR VGND sg13cmos5l_buf_1
XFILLER_36_7 VPWR VGND sg13cmos5l_decap_4
X_1994_ _2446_/B _1991_/Y _1993_/X _2077_/A VPWR VGND sg13cmos5l_o21ai_1
XFILLER_9_293 VPWR VGND sg13cmos5l_fill_1
X_2615_ _3333_/D _2612_/A _2676_/A2 _2614_/Y VPWR VGND sg13cmos5l_a21o_1
X_2546_ _2547_/D _1924_/B _2132_/X _2133_/X _2150_/B VPWR VGND sg13cmos5l_a22oi_1
X_2477_ _2553_/C _2477_/A _2498_/A VPWR VGND sg13cmos5l_nor2_1
XFILLER_34_14 VPWR VGND sg13cmos5l_decap_8
XFILLER_34_25 VPWR VGND sg13cmos5l_fill_1
X_3029_ _3029_/Y _3033_/A _3029_/B VPWR VGND sg13cmos5l_xnor2_1
XFILLER_11_204 VPWR VGND sg13cmos5l_decap_4
XFILLER_11_226 VPWR VGND sg13cmos5l_decap_8
XFILLER_34_69 VPWR VGND sg13cmos5l_decap_4
Xclkload2 clkload2/Y clkload2/A VPWR VGND sg13cmos5l_inv_1
XFILLER_46_112 VPWR VGND sg13cmos5l_decap_8
XFILLER_10_281 VPWR VGND sg13cmos5l_fill_1
XFILLER_24_80 VPWR VGND sg13cmos5l_decap_4
XFILLER_40_90 VPWR VGND sg13cmos5l_decap_8
XFILLER_6_230 VPWR VGND sg13cmos5l_decap_4
X_2400_ _2439_/A _2400_/A _2400_/B _2400_/C VPWR VGND sg13cmos5l_nor3_1
XFILLER_34_4 VPWR VGND sg13cmos5l_decap_4
X_2262_ _2277_/C _2468_/B _2677_/A VPWR VGND sg13cmos5l_nor2b_1
X_2331_ _2331_/Y _2023_/B _3254_/B VPWR VGND sg13cmos5l_nand2b_1
X_3380_ _3380_/Q _3383_/CLK _3380_/D fanout170/X VPWR VGND sg13cmos5l_dfrbpq_1
X_2193_ _2476_/A _3026_/B _2361_/A VPWR VGND sg13cmos5l_nor2_1
X_1977_ _1988_/B _2037_/A _1977_/B VPWR VGND sg13cmos5l_nand2_1
X_2529_ _2531_/C _2555_/A _2555_/B _2555_/C VPWR VGND sg13cmos5l_nor3_1
XFILLER_28_123 VPWR VGND sg13cmos5l_decap_8
XFILLER_45_57 VPWR VGND sg13cmos5l_fill_1
XFILLER_45_79 VPWR VGND sg13cmos5l_decap_8
XFILLER_15_384 VPWR VGND sg13cmos5l_decap_8
XFILLER_34_159 VPWR VGND sg13cmos5l_fill_2
XFILLER_35_90 VPWR VGND sg13cmos5l_decap_8
X_1831_ _1831_/Y _3180_/B _1831_/B VPWR VGND sg13cmos5l_nand2_1
X_1900_ _2006_/B _2941_/B _1900_/B VPWR VGND sg13cmos5l_xnor2_1
X_2880_ _2880_/Y _2885_/A _2885_/D _2925_/B VPWR VGND sg13cmos5l_o21ai_1
X_1693_ _1693_/Y _2103_/D VPWR VGND sg13cmos5l_inv_1
X_1762_ _1862_/B _2007_/A _2028_/A _1865_/B VPWR VGND sg13cmos5l_and3_1
X_3363_ _3363_/Q _3365_/CLK _3363_/D fanout163/X VPWR VGND sg13cmos5l_dfrbpq_1
X_2176_ _2512_/B _2184_/A _2351_/A VPWR VGND sg13cmos5l_nor2_1
X_2245_ _2522_/C _2401_/B _2245_/B VPWR VGND sg13cmos5l_nand2_1
X_2314_ _2397_/B _2314_/A _2314_/B _2314_/C VPWR VGND sg13cmos5l_nand3_1
X_3294_ _3328_/D _2573_/A _3294_/A2 _3293_/Y VPWR VGND sg13cmos5l_a21o_1
XFILLER_33_181 VPWR VGND sg13cmos5l_decap_4
XFILLER_21_343 VPWR VGND sg13cmos5l_fill_2
XFILLER_16_126 VPWR VGND sg13cmos5l_fill_1
XFILLER_12_332 VPWR VGND sg13cmos5l_decap_8
XFILLER_24_192 VPWR VGND sg13cmos5l_fill_2
XFILLER_8_303 VPWR VGND sg13cmos5l_decap_4
XFILLER_8_325 VPWR VGND sg13cmos5l_fill_2
XFILLER_21_92 VPWR VGND sg13cmos5l_fill_1
XFILLER_8_358 VPWR VGND sg13cmos5l_fill_1
XFILLER_39_207 VPWR VGND sg13cmos5l_decap_8
X_2030_ _2030_/Y _2027_/Y _2029_/Y _2026_/Y VPWR VGND sg13cmos5l_o21ai_1
XFILLER_15_170 VPWR VGND sg13cmos5l_decap_4
X_2932_ _2932_/Y _2932_/A _2932_/B _2932_/C VPWR VGND sg13cmos5l_nor3_1
X_1745_ _2214_/B _3422_/Q _3421_/Q VPWR VGND sg13cmos5l_nor2b_1
X_1814_ _2322_/A _1816_/A _3181_/A VPWR VGND sg13cmos5l_xnor2_1
X_2863_ _2863_/Y _3367_/Q _2863_/B VPWR VGND sg13cmos5l_nand2_1
X_2794_ _2860_/A _2812_/A _2852_/B VPWR VGND sg13cmos5l_nand2_1
X_1676_ _3100_/A _2947_/A VPWR VGND sg13cmos5l_inv_1
Xhold369 hold369/X _3328_/Q VPWR VGND sg13cmos5l_dlygate4sd3_1
Xhold358 hold358/X _3300_/Q VPWR VGND sg13cmos5l_dlygate4sd3_1
Xhold347 hold347/X _3385_/Q VPWR VGND sg13cmos5l_dlygate4sd3_1
Xhold336 _2612_/A _3333_/Q VPWR VGND sg13cmos5l_dlygate4sd3_1
Xhold325 hold325/X _2837_/B VPWR VGND sg13cmos5l_dlygate4sd3_1
Xhold314 _3390_/D _2866_/Y VPWR VGND sg13cmos5l_dlygate4sd3_1
Xhold303 hold303/X _3452_/A VPWR VGND sg13cmos5l_dlygate4sd3_1
X_3415_ _3415_/Q _3416_/CLK _3415_/D fanout172/X VPWR VGND sg13cmos5l_dfrbpq_1
X_3346_ _3346_/Q _3349_/CLK _3346_/D fanout164/X VPWR VGND sg13cmos5l_dfrbpq_1
X_2159_ _2542_/A _2363_/B _2245_/B VPWR VGND sg13cmos5l_nand2_1
X_2228_ _2236_/C _2485_/A _2487_/A _2239_/A _2228_/D VPWR VGND sg13cmos5l_nor4_1
X_3277_ _3278_/A _3276_/A _3276_/Y _3277_/S VPWR VGND sg13cmos5l_mux2_1
XFILLER_42_14 VPWR VGND sg13cmos5l_decap_8
XFILLER_42_69 VPWR VGND sg13cmos5l_decap_8
XFILLER_21_173 VPWR VGND sg13cmos5l_decap_4
XFILLER_17_402 VPWR VGND sg13cmos5l_fill_2
XFILLER_32_91 VPWR VGND sg13cmos5l_decap_8
X_3200_ _3200_/Y _3381_/Q _3200_/B VPWR VGND sg13cmos5l_nor2_1
X_2013_ _2013_/Y _2027_/A _2027_/B _2016_/A VPWR VGND sg13cmos5l_nor3_1
X_3131_ _3171_/D _3171_/C _3130_/Y _3129_/Y VPWR VGND sg13cmos5l_a21oi_1
X_3062_ _3062_/Y _3057_/Y _3060_/Y _3061_/Y VPWR VGND sg13cmos5l_o21ai_1
X_2915_ _2915_/Y _2910_/Y hold308/X _2917_/B VPWR VGND sg13cmos5l_o21ai_1
X_1728_ _2684_/B _1736_/B _1730_/A VPWR VGND sg13cmos5l_nand2_1
X_2846_ _2850_/B _3165_/A _3124_/A _2857_/C VPWR VGND sg13cmos5l_and3_1
X_2777_ _3369_/D _2777_/A VPWR VGND sg13cmos5l_inv_1
X_1659_ _2068_/A _2573_/A VPWR VGND sg13cmos5l_inv_1
X_3329_ _3329_/Q _3419_/CLK _3329_/D fanout168/X VPWR VGND sg13cmos5l_dfrbpq_1
XFILLER_37_36 VPWR VGND sg13cmos5l_decap_8
XFILLER_32_213 VPWR VGND sg13cmos5l_fill_2
XFILLER_32_246 VPWR VGND sg13cmos5l_decap_4
X_2700_ _2700_/Y _1687_/Y _2757_/A2 _2699_/Y _2678_/Y VPWR VGND sg13cmos5l_a22oi_1
X_2631_ _3336_/D _2628_/A _2671_/A2 _2630_/Y VPWR VGND sg13cmos5l_a21o_1
X_2562_ _2563_/D _2562_/A _2562_/B _2562_/C _2562_/D VPWR VGND sg13cmos5l_and4_1
X_2493_ _2501_/A _2493_/A _2493_/B _2493_/C _2493_/D VPWR VGND sg13cmos5l_nand4_1
X_3114_ _3114_/Y _1903_/B _3097_/Y _3112_/Y _3113_/Y VPWR VGND sg13cmos5l_a22oi_1
X_3045_ _3045_/Y _1663_/Y _3089_/B _3272_/A VPWR VGND sg13cmos5l_a21oi_1
Xclkbuf_5_18__f_clk _3379_/CLK clkbuf_4_9_0_clk/X VPWR VGND sg13cmos5l_buf_8
X_2829_ _2830_/B _3272_/A _2829_/B VPWR VGND sg13cmos5l_xnor2_1
XFILLER_14_213 VPWR VGND sg13cmos5l_decap_8
XFILLER_14_268 VPWR VGND sg13cmos5l_decap_8
XFILLER_13_60 VPWR VGND sg13cmos5l_fill_1
Xfanout50 _2369_/A _2446_/D VPWR VGND sg13cmos5l_buf_1
Xfanout61 _2274_/C _1716_/Y VPWR VGND sg13cmos5l_buf_1
Xfanout72 _1933_/B _1665_/Y VPWR VGND sg13cmos5l_buf_1
Xfanout83 _3168_/C hold338/X VPWR VGND sg13cmos5l_buf_1
Xfanout94 _3180_/A _3376_/Q VPWR VGND sg13cmos5l_buf_1
X_1993_ _1993_/X _2639_/A _2092_/A _1993_/C VPWR VGND sg13cmos5l_and3_1
X_2614_ _2614_/Y _3293_/A _2614_/B VPWR VGND sg13cmos5l_nor2_1
X_2545_ _2547_/C _1924_/B _2198_/B _2520_/C VPWR VGND sg13cmos5l_a21oi_1
X_2476_ _2483_/C _2476_/A _2476_/B _2476_/C _2476_/D VPWR VGND sg13cmos5l_nand4_1
XFILLER_34_48 VPWR VGND sg13cmos5l_decap_8
X_3028_ _3029_/B _3028_/A _3028_/B VPWR VGND sg13cmos5l_xor2_1
Xclkload3 clkload3/Y clkload3/A VPWR VGND sg13cmos5l_inv_1
XFILLER_19_316 VPWR VGND sg13cmos5l_fill_2
XFILLER_19_338 VPWR VGND sg13cmos5l_decap_8
XFILLER_46_135 VPWR VGND sg13cmos5l_fill_1
XFILLER_6_264 VPWR VGND sg13cmos5l_fill_1
XFILLER_37_102 VPWR VGND sg13cmos5l_fill_2
X_2192_ _2361_/A _2558_/A _2192_/B VPWR VGND sg13cmos5l_nor2_1
X_2261_ _2677_/A _2369_/C _2380_/A _2369_/A VPWR VGND sg13cmos5l_nand3b_1
X_2330_ _2330_/Y _2023_/B _2080_/Y _2082_/Y _2006_/B VPWR VGND sg13cmos5l_a22oi_1
XFILLER_18_371 VPWR VGND sg13cmos5l_decap_8
XFILLER_37_146 VPWR VGND sg13cmos5l_decap_8
XFILLER_37_157 VPWR VGND sg13cmos5l_fill_1
X_1976_ _1977_/B _2049_/B _2066_/B VPWR VGND sg13cmos5l_nor2b_1
X_2528_ _2538_/B _2528_/A _2528_/B VPWR VGND sg13cmos5l_nand2_1
XFILLER_45_25 VPWR VGND sg13cmos5l_decap_8
XFILLER_45_36 VPWR VGND sg13cmos5l_fill_1
X_2459_ _2460_/A _2239_/A _2459_/B VPWR VGND sg13cmos5l_nand2b_1
XFILLER_45_69 VPWR VGND sg13cmos5l_decap_4
XFILLER_6_19 VPWR VGND sg13cmos5l_fill_1
XFILLER_15_341 VPWR VGND sg13cmos5l_fill_1
XFILLER_15_363 VPWR VGND sg13cmos5l_decap_8
XFILLER_30_311 VPWR VGND sg13cmos5l_fill_1
XFILLER_30_322 VPWR VGND sg13cmos5l_fill_2
X_1761_ _1781_/B _1816_/A _3181_/A _2628_/A VPWR VGND sg13cmos5l_a21o_1
X_1830_ _1937_/B _2302_/B _2993_/C VPWR VGND sg13cmos5l_nand2_1
X_1692_ _1965_/B _2606_/A VPWR VGND sg13cmos5l_inv_1
X_2313_ _2314_/C _2310_/Y _2312_/Y _2302_/Y VPWR VGND sg13cmos5l_a21o_1
X_3362_ _3362_/Q clkload0/A _3362_/D fanout163/X VPWR VGND sg13cmos5l_dfrbpq_1
XFILLER_18_0 VPWR VGND sg13cmos5l_fill_2
X_2175_ _2510_/B _2351_/A _2175_/B VPWR VGND sg13cmos5l_nor2_1
X_2244_ _2396_/B _2244_/A _2244_/B _2244_/C VPWR VGND sg13cmos5l_nor3_1
X_3293_ _3293_/Y _3293_/A _3293_/B VPWR VGND sg13cmos5l_nor2_1
XFILLER_40_108 VPWR VGND sg13cmos5l_fill_1
X_1959_ _1972_/B _1975_/A _3324_/Q _2037_/A VPWR VGND sg13cmos5l_o21ai_1
XFILLER_12_322 VPWR VGND sg13cmos5l_fill_2
XFILLER_12_355 VPWR VGND sg13cmos5l_decap_8
Xclkbuf_0_clk clkbuf_0_clk/X clk VPWR VGND sg13cmos5l_buf_8
X_2931_ _2931_/Y _2932_/B hold222/X _2929_/Y VPWR VGND sg13cmos5l_o21ai_1
XFILLER_30_163 VPWR VGND sg13cmos5l_decap_8
X_1744_ _2147_/A _3424_/Q _3423_/Q VPWR VGND sg13cmos5l_nand2b_1
X_1813_ _1813_/Y _3008_/A _1866_/B VPWR VGND sg13cmos5l_nand2_1
Xhold326 _3382_/D _2839_/Y VPWR VGND sg13cmos5l_dlygate4sd3_1
Xhold315 hold315/X _3369_/Q VPWR VGND sg13cmos5l_dlygate4sd3_1
Xhold304 _2617_/B _3334_/Q VPWR VGND sg13cmos5l_dlygate4sd3_1
X_2862_ _2913_/B _3367_/Q _2863_/B VPWR VGND sg13cmos5l_and2_1
X_2793_ _2806_/A _2812_/A _2852_/B VPWR VGND sg13cmos5l_and2_1
X_1675_ _2007_/B _2952_/A VPWR VGND sg13cmos5l_inv_1
Xhold359 hold359/X _3365_/Q VPWR VGND sg13cmos5l_dlygate4sd3_1
Xhold348 _2847_/B _2845_/Y VPWR VGND sg13cmos5l_dlygate4sd3_1
Xhold337 hold337/X _3362_/Q VPWR VGND sg13cmos5l_dlygate4sd3_1
X_3414_ _3414_/Q clkload1/A _3414_/D fanout167/X VPWR VGND sg13cmos5l_dfrbpq_1
X_3345_ _3345_/Q _3349_/CLK _3345_/D fanout164/X VPWR VGND sg13cmos5l_dfrbpq_1
X_3276_ _3276_/Y _3276_/A _3276_/B VPWR VGND sg13cmos5l_nand2_1
X_2089_ _2315_/C _2286_/A _2289_/B _2639_/A VPWR VGND sg13cmos5l_a21o_1
X_2158_ _2158_/Y _2178_/B _2158_/B VPWR VGND sg13cmos5l_nand2_1
X_2227_ _2228_/D _2430_/A _2553_/A _2227_/C _2227_/D VPWR VGND sg13cmos5l_nand4_1
XFILLER_21_141 VPWR VGND sg13cmos5l_decap_8
XFILLER_44_211 VPWR VGND sg13cmos5l_fill_1
XFILLER_32_70 VPWR VGND sg13cmos5l_decap_8
XFILLER_8_123 VPWR VGND sg13cmos5l_fill_2
X_3130_ _3130_/Y _3138_/B _3130_/B VPWR VGND sg13cmos5l_nor2_1
XFILLER_35_200 VPWR VGND sg13cmos5l_fill_1
X_2012_ _2016_/A _2028_/A _2315_/A VPWR VGND sg13cmos5l_xnor2_1
X_3061_ _3061_/Y _3180_/A _1937_/B _1834_/A _3253_/A1 VPWR VGND sg13cmos5l_a22oi_1
X_2914_ _2917_/B _2926_/B _2926_/C VPWR VGND sg13cmos5l_nand2_1
X_2845_ _2845_/Y _3165_/A _2857_/C _3124_/A VPWR VGND sg13cmos5l_a21oi_1
X_1658_ _2064_/A _2586_/A VPWR VGND sg13cmos5l_inv_1
X_1727_ _2570_/A _3415_/D _1732_/B VPWR VGND sg13cmos5l_nor2_1
X_2776_ _2777_/A hold315/X _1737_/B _3276_/B VPWR VGND sg13cmos5l_o21ai_1
X_3328_ _3328_/Q _3416_/CLK _3328_/D fanout168/X VPWR VGND sg13cmos5l_dfrbpq_1
X_3259_ _3263_/C _3259_/A _3259_/B _3259_/C _3259_/D VPWR VGND sg13cmos5l_nand4_1
XFILLER_26_200 VPWR VGND sg13cmos5l_fill_1
XFILLER_26_244 VPWR VGND sg13cmos5l_decap_8
XFILLER_5_148 VPWR VGND sg13cmos5l_fill_2
XFILLER_27_70 VPWR VGND sg13cmos5l_fill_1
X_2630_ _2630_/Y _2626_/X _2628_/X _2629_/Y VPWR VGND sg13cmos5l_a21oi_1
X_2561_ _2562_/D _2561_/A _2561_/B VPWR VGND sg13cmos5l_nor2_1
X_2492_ _2493_/D _2438_/B _2245_/B _2179_/B _2139_/B _2437_/A VPWR VGND sg13cmos5l_a221oi_1
X_3113_ _3113_/Y _3089_/A _2006_/B _2023_/B _3254_/A VPWR VGND sg13cmos5l_a22oi_1
XFILLER_23_214 VPWR VGND sg13cmos5l_decap_4
X_3044_ _3044_/Y _3044_/A _3268_/B VPWR VGND sg13cmos5l_nand2_1
XFILLER_23_258 VPWR VGND sg13cmos5l_decap_8
X_2828_ _3378_/D _2844_/B _2828_/B _2829_/B VPWR VGND sg13cmos5l_nor3_1
X_2759_ _2759_/Y _2761_/A _2722_/B _2725_/Y _2738_/X _2170_/Y VPWR VGND sg13cmos5l_a221oi_1
XFILLER_48_47 VPWR VGND sg13cmos5l_fill_1
XFILLER_14_203 VPWR VGND sg13cmos5l_fill_2
Xfanout40 _3190_/B _1889_/B VPWR VGND sg13cmos5l_buf_1
Xfanout51 _2265_/A _2115_/X VPWR VGND sg13cmos5l_buf_1
Xfanout62 _2413_/A _1716_/Y VPWR VGND sg13cmos5l_buf_1
Xfanout73 _2646_/A _1651_/Y VPWR VGND sg13cmos5l_buf_1
XFILLER_6_402 VPWR VGND sg13cmos5l_fill_2
Xfanout84 _3204_/A _3383_/Q VPWR VGND sg13cmos5l_buf_1
Xfanout95 _3137_/A _3145_/A VPWR VGND sg13cmos5l_buf_1
Xclkbuf_5_24__f_clk _3413_/CLK clkbuf_4_12_0_clk/X VPWR VGND sg13cmos5l_buf_8
XFILLER_20_217 VPWR VGND sg13cmos5l_decap_8
XFILLER_9_240 VPWR VGND sg13cmos5l_fill_1
X_1992_ _1993_/C _1816_/A _2628_/A _2633_/A VPWR VGND sg13cmos5l_o21ai_1
XFILLER_48_0 VPWR VGND sg13cmos5l_decap_8
X_2613_ _2614_/B _2613_/A _2613_/B VPWR VGND sg13cmos5l_xnor2_1
X_2544_ _2550_/B _2544_/A _2544_/B _2544_/C _2544_/D VPWR VGND sg13cmos5l_nor4_1
X_2475_ _2476_/D _2240_/A _2265_/A _2369_/A _2206_/A _2512_/B VPWR VGND sg13cmos5l_a221oi_1
X_3027_ _3035_/A _3028_/A _3041_/B VPWR VGND sg13cmos5l_nor2_1
Xclkload4 clkload4/Y clkload4/A VPWR VGND sg13cmos5l_inv_1
XFILLER_46_103 VPWR VGND sg13cmos5l_fill_2
XFILLER_40_70 VPWR VGND sg13cmos5l_fill_1
XFILLER_41_7 VPWR VGND sg13cmos5l_fill_2
X_2191_ _2191_/X input2/X _2544_/B VPWR VGND sg13cmos5l_and2_1
X_2260_ _2468_/B _2369_/C _2524_/B VPWR VGND sg13cmos5l_nor2b_1
XFILLER_1_86 VPWR VGND sg13cmos5l_fill_1
XFILLER_33_353 VPWR VGND sg13cmos5l_fill_1
X_1975_ _2066_/B _1975_/A _3324_/Q VPWR VGND sg13cmos5l_nand2_1
X_2527_ _2527_/Y _2568_/S _2527_/B VPWR VGND sg13cmos5l_nand2b_1
X_2458_ _2934_/A _2770_/A VPWR VGND sg13cmos5l_inv_1
X_2389_ _2430_/D _2389_/A _2499_/C _2389_/C VPWR VGND sg13cmos5l_nor3_1
XFILLER_3_246 VPWR VGND sg13cmos5l_fill_2
XFILLER_27_191 VPWR VGND sg13cmos5l_decap_8
XFILLER_34_106 VPWR VGND sg13cmos5l_decap_4
XFILLER_15_397 VPWR VGND sg13cmos5l_decap_8
X_1691_ _2054_/A _3333_/Q VPWR VGND sg13cmos5l_inv_1
X_1760_ _1760_/Y _2077_/A _2079_/A VPWR VGND sg13cmos5l_nand2_1
X_2312_ _2312_/Y _1834_/A _2082_/Y _2311_/Y VPWR VGND sg13cmos5l_a21oi_1
X_3361_ _3361_/Q _3365_/CLK _3361_/D fanout165/X VPWR VGND sg13cmos5l_dfrbpq_1
X_3292_ _3293_/B _3292_/A _3292_/B VPWR VGND sg13cmos5l_xnor2_1
X_2174_ _2432_/A _2369_/C _2512_/A VPWR VGND sg13cmos5l_and2_1
X_2243_ _2497_/B _2401_/B _2412_/B VPWR VGND sg13cmos5l_nand2_1
XFILLER_21_356 VPWR VGND sg13cmos5l_decap_8
XFILLER_21_367 VPWR VGND sg13cmos5l_fill_1
XFILLER_31_39 VPWR VGND sg13cmos5l_fill_1
X_1889_ _1889_/Y _2318_/A _1889_/B VPWR VGND sg13cmos5l_xnor2_1
X_1958_ _2049_/B _1975_/A _3324_/Q VPWR VGND sg13cmos5l_nor2_1
XFILLER_0_238 VPWR VGND sg13cmos5l_fill_1
XFILLER_24_183 VPWR VGND sg13cmos5l_fill_1
XFILLER_47_286 VPWR VGND sg13cmos5l_fill_2
XFILLER_15_194 VPWR VGND sg13cmos5l_fill_2
XFILLER_30_120 VPWR VGND sg13cmos5l_decap_8
X_2930_ _2930_/Y _3367_/Q _2928_/C _2928_/A VPWR VGND sg13cmos5l_o21ai_1
X_2861_ _2892_/B _2874_/A _2874_/C VPWR VGND sg13cmos5l_nand2_1
X_1674_ _3116_/A _3098_/A VPWR VGND sg13cmos5l_inv_1
X_1743_ _2134_/B _3424_/Q _3423_/Q VPWR VGND sg13cmos5l_nor2b_1
X_1812_ _1812_/Y _3008_/A _1866_/B VPWR VGND sg13cmos5l_nor2_1
Xhold349 _2606_/A _3332_/Q VPWR VGND sg13cmos5l_dlygate4sd3_1
Xhold338 hold338/X _3383_/Q VPWR VGND sg13cmos5l_dlygate4sd3_1
Xhold327 _2673_/A _3343_/Q VPWR VGND sg13cmos5l_dlygate4sd3_1
Xhold316 _2885_/A _3395_/Q VPWR VGND sg13cmos5l_dlygate4sd3_1
Xhold305 _2976_/A _3302_/Q VPWR VGND sg13cmos5l_dlygate4sd3_1
X_3413_ _3413_/Q _3413_/CLK _3413_/D fanout183/X VPWR VGND sg13cmos5l_dfrbpq_1
X_2792_ _2821_/B _2792_/A _2792_/B _2832_/B VPWR VGND sg13cmos5l_nand3_1
XFILLER_30_0 VPWR VGND sg13cmos5l_fill_2
X_2226_ _2227_/D _2226_/A _2226_/B _2536_/A _2226_/D VPWR VGND sg13cmos5l_nor4_1
X_3344_ _3344_/Q _3349_/CLK _3344_/D fanout164/X VPWR VGND sg13cmos5l_dfrbpq_1
X_3275_ _3322_/D _3275_/A _3275_/B VPWR VGND sg13cmos5l_nand2_1
XFILLER_38_231 VPWR VGND sg13cmos5l_fill_1
X_2088_ _2092_/C _2007_/A _1817_/X _1780_/X VPWR VGND sg13cmos5l_a21o_1
X_2157_ _2245_/B _2157_/A _2157_/B VPWR VGND sg13cmos5l_nor2_1
XFILLER_42_38 VPWR VGND sg13cmos5l_decap_8
XFILLER_42_49 VPWR VGND sg13cmos5l_fill_1
XFILLER_29_253 VPWR VGND sg13cmos5l_fill_2
Xclkbuf_5_5__f_clk clkload1/A clkbuf_4_2_0_clk/X VPWR VGND sg13cmos5l_buf_8
XFILLER_4_352 VPWR VGND sg13cmos5l_fill_2
X_3060_ _3060_/Y _3180_/A _1937_/B _3058_/Y VPWR VGND sg13cmos5l_o21ai_1
X_2011_ _2027_/B _2007_/A _2007_/B _2008_/Y _2009_/Y _2010_/Y VPWR VGND sg13cmos5l_a221oi_1
X_2913_ _2913_/Y _2913_/A _2913_/B VPWR VGND sg13cmos5l_nor2_1
X_2844_ _3384_/D _2849_/A _2844_/B _2844_/C VPWR VGND sg13cmos5l_nor3_1
X_1657_ _2062_/A _2594_/A VPWR VGND sg13cmos5l_inv_1
X_1726_ _1732_/B _3419_/D _3417_/D _3418_/D VPWR VGND sg13cmos5l_or3_1
X_2775_ _3368_/D hold276/X _3276_/B _3429_/D VPWR VGND sg13cmos5l_a21o_1
XFILLER_37_16 VPWR VGND sg13cmos5l_fill_2
X_2209_ _2256_/A _2369_/C _2524_/B VPWR VGND sg13cmos5l_nand2_1
X_3327_ _3327_/Q _3327_/CLK _3327_/D fanout168/X VPWR VGND sg13cmos5l_dfrbpq_1
X_3258_ _3259_/D _3258_/A _3258_/B VPWR VGND sg13cmos5l_nor2_1
X_3189_ _3189_/Y _3145_/A _1765_/Y _1780_/X _3054_/B _3188_/Y VPWR VGND sg13cmos5l_a221oi_1
XFILLER_41_204 VPWR VGND sg13cmos5l_fill_1
XFILLER_1_333 VPWR VGND sg13cmos5l_fill_2
XFILLER_32_215 VPWR VGND sg13cmos5l_fill_1
X_2560_ _2561_/B _2560_/A _2560_/B _2560_/C _2560_/D VPWR VGND sg13cmos5l_nand4_1
X_2491_ _2528_/B _2559_/B _2491_/B VPWR VGND sg13cmos5l_nor2_1
X_3112_ _3112_/Y _3112_/A _3112_/B VPWR VGND sg13cmos5l_nand2_1
X_3043_ _3043_/Y _3023_/A _3042_/Y _3039_/Y VPWR VGND sg13cmos5l_o21ai_1
X_2827_ _2829_/B _2827_/A _3272_/B VPWR VGND sg13cmos5l_nor2_1
X_2758_ _2758_/Y _2758_/A _2758_/B VPWR VGND sg13cmos5l_nand2_1
XFILLER_48_15 VPWR VGND sg13cmos5l_fill_2
X_1709_ _3224_/A _3121_/A VPWR VGND sg13cmos5l_inv_1
X_2689_ _2689_/Y _3358_/Q _2750_/S _2693_/B VPWR VGND sg13cmos5l_a21oi_1
XFILLER_14_248 VPWR VGND sg13cmos5l_decap_8
Xfanout30 _3041_/B _3028_/B VPWR VGND sg13cmos5l_buf_1
Xfanout41 _2667_/B _2673_/B VPWR VGND sg13cmos5l_buf_1
Xfanout52 _2363_/A _2115_/X VPWR VGND sg13cmos5l_buf_1
Xfanout63 _2925_/B _2863_/Y VPWR VGND sg13cmos5l_buf_1
Xfanout74 _2098_/A _3426_/Q VPWR VGND sg13cmos5l_buf_1
Xfanout85 _3121_/A _3382_/Q VPWR VGND sg13cmos5l_buf_1
Xfanout96 _3145_/A _3375_/Q VPWR VGND sg13cmos5l_buf_1
XFILLER_8_0 VPWR VGND sg13cmos5l_fill_1
XFILLER_49_123 VPWR VGND sg13cmos5l_decap_8
XFILLER_49_134 VPWR VGND sg13cmos5l_decap_8
XFILLER_49_145 VPWR VGND sg13cmos5l_fill_2
XFILLER_9_285 VPWR VGND sg13cmos5l_decap_4
X_1991_ _1991_/Y _1991_/A _1991_/B _1991_/C VPWR VGND sg13cmos5l_nor3_1
X_2612_ _2613_/B _2612_/A _2612_/B VPWR VGND sg13cmos5l_xnor2_1
X_2543_ _2544_/D _2543_/A _2543_/B VPWR VGND sg13cmos5l_nand2_1
X_2474_ _2483_/B _2547_/A _2547_/B _2528_/A _2502_/A VPWR VGND sg13cmos5l_nand4_1
X_3026_ _3033_/B _3028_/A _3026_/B VPWR VGND sg13cmos5l_nand2_1
XFILLER_36_384 VPWR VGND sg13cmos5l_fill_2
Xclkload5 clkload5/Y clkload5/A VPWR VGND sg13cmos5l_inv_1
Xclkbuf_5_30__f_clk _3410_/CLK clkbuf_4_15_0_clk/X VPWR VGND sg13cmos5l_buf_8
XFILLER_46_126 VPWR VGND sg13cmos5l_decap_8
XFILLER_18_351 VPWR VGND sg13cmos5l_fill_1
XFILLER_37_104 VPWR VGND sg13cmos5l_fill_1
XFILLER_37_126 VPWR VGND sg13cmos5l_decap_8
X_2190_ _2544_/B _2413_/A _2436_/A VPWR VGND sg13cmos5l_nor2_1
XFILLER_18_384 VPWR VGND sg13cmos5l_decap_8
XFILLER_33_376 VPWR VGND sg13cmos5l_fill_1
X_1974_ _1979_/S _1974_/A _3229_/B VPWR VGND sg13cmos5l_nor2_1
X_2526_ _2527_/B _2526_/A _2565_/A _2565_/B _2526_/D VPWR VGND sg13cmos5l_or4_1
X_2457_ _2770_/A _2457_/A _2461_/B _2457_/C _2457_/D VPWR VGND sg13cmos5l_or4_1
X_2388_ _2447_/C _2388_/A _2207_/B VPWR VGND sg13cmos5l_nor2b_1
XFILLER_36_181 VPWR VGND sg13cmos5l_fill_2
XFILLER_36_192 VPWR VGND sg13cmos5l_fill_2
X_3009_ _3009_/Y _3009_/A _3009_/B VPWR VGND sg13cmos5l_nor2_1
XFILLER_24_376 VPWR VGND sg13cmos5l_fill_1
XFILLER_19_126 VPWR VGND sg13cmos5l_fill_1
XFILLER_27_170 VPWR VGND sg13cmos5l_decap_8
XFILLER_42_184 VPWR VGND sg13cmos5l_decap_8
X_1690_ _1690_/Y _1690_/A VPWR VGND sg13cmos5l_inv_1
X_2242_ _2485_/B _2355_/B _2242_/B VPWR VGND sg13cmos5l_nand2_1
X_2311_ _2311_/Y _1941_/C _2092_/B _2079_/Y _1852_/B VPWR VGND sg13cmos5l_a22oi_1
X_3360_ _3360_/Q _3360_/CLK _3360_/D fanout166/X VPWR VGND sg13cmos5l_dfrbpq_1
X_3291_ _3327_/D _3288_/A _3294_/A2 _3290_/Y VPWR VGND sg13cmos5l_a21o_1
XFILLER_18_2 VPWR VGND sg13cmos5l_fill_1
X_2173_ _2493_/A _2412_/A _2250_/A VPWR VGND sg13cmos5l_nand2_1
XFILLER_33_162 VPWR VGND sg13cmos5l_decap_8
X_1957_ _1980_/A _1957_/A _1957_/B _1957_/C VPWR VGND sg13cmos5l_nand3_1
X_1888_ _1888_/X _1888_/A _1888_/B VPWR VGND sg13cmos5l_and2_1
X_2509_ _2514_/C _2219_/Y _2550_/A _2543_/B VPWR VGND sg13cmos5l_nand3b_1
XFILLER_12_302 VPWR VGND sg13cmos5l_decap_4
XFILLER_12_346 VPWR VGND sg13cmos5l_fill_1
XFILLER_46_92 VPWR VGND sg13cmos5l_decap_8
X_1811_ _1811_/Y _1933_/B _3015_/A _1808_/Y _1810_/Y VPWR VGND sg13cmos5l_a22oi_1
X_2860_ _3389_/D _2860_/A _2860_/B VPWR VGND sg13cmos5l_nor2_1
X_2791_ _2844_/B _3276_/B _2791_/B VPWR VGND sg13cmos5l_nor2_1
X_1673_ _2318_/A _2963_/A VPWR VGND sg13cmos5l_inv_1
X_1742_ _1742_/Y _2098_/A _2150_/B VPWR VGND sg13cmos5l_nand2_1
Xhold339 _3383_/D _2841_/Y VPWR VGND sg13cmos5l_dlygate4sd3_1
Xhold328 _3276_/A _3323_/Q VPWR VGND sg13cmos5l_dlygate4sd3_1
Xhold317 _3395_/D _2881_/X VPWR VGND sg13cmos5l_dlygate4sd3_1
Xhold306 _2375_/A _3366_/Q VPWR VGND sg13cmos5l_dlygate4sd3_1
X_3412_ _3412_/Q _3412_/CLK _3412_/D fanout179/X VPWR VGND sg13cmos5l_dfrbpq_1
X_2225_ _2226_/D _2225_/A _2392_/A _2225_/C VPWR VGND sg13cmos5l_nand3_1
X_3343_ _3343_/Q _3423_/CLK _3343_/D fanout181/X VPWR VGND sg13cmos5l_dfrbpq_1
X_3274_ _3275_/B _3274_/A _3274_/B _3274_/C VPWR VGND sg13cmos5l_nand3_1
X_2087_ _2244_/C _3254_/B _2086_/X _2092_/B VPWR VGND sg13cmos5l_o21ai_1
X_2156_ _2540_/A _2450_/A _2265_/A VPWR VGND sg13cmos5l_nand2_1
XFILLER_21_198 VPWR VGND sg13cmos5l_fill_2
XFILLER_42_28 VPWR VGND sg13cmos5l_decap_4
X_2989_ _2998_/A input2/X input3/X _2544_/B VPWR VGND sg13cmos5l_o21ai_1
XFILLER_29_221 VPWR VGND sg13cmos5l_fill_1
XFILLER_29_232 VPWR VGND sg13cmos5l_fill_2
XFILLER_29_298 VPWR VGND sg13cmos5l_fill_2
XFILLER_44_202 VPWR VGND sg13cmos5l_fill_1
XFILLER_32_61 VPWR VGND sg13cmos5l_fill_1
X_2010_ _2010_/Y _2010_/A _1816_/B VPWR VGND sg13cmos5l_nor2b_1
X_2912_ _3406_/D hold323/X _2910_/B _2911_/Y VPWR VGND sg13cmos5l_a21o_1
X_1725_ _1730_/A _3415_/D _3418_/D VPWR VGND sg13cmos5l_nor2_1
X_2843_ _2844_/C _3165_/A _2857_/C VPWR VGND sg13cmos5l_nor2_1
X_2774_ _3367_/D _2774_/A _2774_/B VPWR VGND sg13cmos5l_nand2_1
X_1656_ _2620_/A _3322_/Q VPWR VGND sg13cmos5l_inv_1
X_3326_ _3326_/Q _3327_/CLK _3326_/D fanout168/X VPWR VGND sg13cmos5l_dfrbpq_1
XFILLER_26_213 VPWR VGND sg13cmos5l_decap_8
XFILLER_26_224 VPWR VGND sg13cmos5l_fill_2
X_2139_ _2435_/B _3425_/Q _2139_/B VPWR VGND sg13cmos5l_nand2b_1
X_2208_ _2524_/B _2208_/A _2435_/B VPWR VGND sg13cmos5l_nor2_1
X_3257_ _3258_/B _3257_/A _3257_/B _3257_/C VPWR VGND sg13cmos5l_nand3_1
X_3188_ _3188_/Y _3146_/A _1823_/B _3187_/Y VPWR VGND sg13cmos5l_a21oi_1
XFILLER_40_282 VPWR VGND sg13cmos5l_fill_1
X_2490_ _2491_/B _2196_/A _2379_/B _1742_/Y VPWR VGND sg13cmos5l_a21oi_1
X_3111_ _3112_/B _3091_/A _1896_/X _1899_/Y _3115_/B VPWR VGND sg13cmos5l_a22oi_1
X_3042_ _3042_/Y _3042_/A _3042_/B VPWR VGND sg13cmos5l_xnor2_1
XFILLER_31_260 VPWR VGND sg13cmos5l_fill_2
XFILLER_31_271 VPWR VGND sg13cmos5l_fill_1
X_1708_ _3168_/A _3165_/A VPWR VGND sg13cmos5l_inv_1
X_2826_ _3272_/B _3269_/A _2826_/B VPWR VGND sg13cmos5l_or2_1
X_2757_ _3360_/D hold335/X _2757_/A2 _2756_/Y VPWR VGND sg13cmos5l_a21o_1
X_2688_ _2699_/B _2693_/B _3360_/Q _2751_/B VPWR VGND sg13cmos5l_nand3_1
X_3309_ _3309_/Q _3335_/CLK _3309_/D fanout184/X VPWR VGND sg13cmos5l_dfrbpq_1
XFILLER_10_400 VPWR VGND sg13cmos5l_decap_4
Xfanout20 _2767_/B _2758_/B VPWR VGND sg13cmos5l_buf_1
Xfanout31 _3028_/B _3026_/B VPWR VGND sg13cmos5l_buf_1
Xfanout42 _2673_/B _2646_/B VPWR VGND sg13cmos5l_buf_1
Xfanout53 _2206_/A _2248_/A VPWR VGND sg13cmos5l_buf_1
Xfanout64 _2907_/B _2863_/Y VPWR VGND sg13cmos5l_buf_1
Xfanout75 _3156_/A _3389_/Q VPWR VGND sg13cmos5l_buf_1
Xfanout86 _3199_/A _3381_/Q VPWR VGND sg13cmos5l_buf_1
Xfanout97 _3138_/B _3145_/B VPWR VGND sg13cmos5l_buf_1
XFILLER_38_93 VPWR VGND sg13cmos5l_decap_8
XFILLER_49_102 VPWR VGND sg13cmos5l_decap_8
X_1990_ _1991_/C _2622_/A _2628_/A _2633_/A VPWR VGND sg13cmos5l_a21oi_1
XFILLER_9_231 VPWR VGND sg13cmos5l_fill_1
XFILLER_9_275 VPWR VGND sg13cmos5l_fill_2
X_2611_ _2613_/A _1965_/B _2606_/B _2609_/B VPWR VGND sg13cmos5l_o21ai_1
X_2542_ _2544_/C _2542_/A _2542_/B VPWR VGND sg13cmos5l_nand2_1
X_2473_ _2502_/A _2216_/A _2099_/X _2415_/B _2401_/A _2453_/C VPWR VGND sg13cmos5l_a221oi_1
X_3025_ _3033_/A _3019_/A _3041_/B _3023_/B VPWR VGND sg13cmos5l_a21oi_1
Xclkload6 clkload6/Y clkload6/A VPWR VGND sg13cmos5l_inv_1
X_2809_ _3373_/D _2807_/A _2807_/B _2808_/Y VPWR VGND sg13cmos5l_a21oi_1
XFILLER_24_84 VPWR VGND sg13cmos5l_fill_2
XFILLER_40_61 VPWR VGND sg13cmos5l_decap_8
XFILLER_6_223 VPWR VGND sg13cmos5l_decap_8
XFILLER_6_234 VPWR VGND sg13cmos5l_fill_1
XFILLER_34_8 VPWR VGND sg13cmos5l_fill_1
XFILLER_40_83 VPWR VGND sg13cmos5l_decap_8
XFILLER_41_9 VPWR VGND sg13cmos5l_fill_1
XFILLER_49_81 VPWR VGND sg13cmos5l_decap_8
XFILLER_1_66 VPWR VGND sg13cmos5l_fill_2
X_1973_ _3229_/B _2068_/A _1973_/B VPWR VGND sg13cmos5l_xnor2_1
X_2525_ _2526_/D _3275_/A _2525_/B _2525_/C _2525_/D VPWR VGND sg13cmos5l_nand4_1
X_2456_ _3427_/D _2456_/A _2456_/B _2456_/C _2456_/D VPWR VGND sg13cmos5l_nand4_1
X_2387_ _2390_/B _2419_/A _2387_/B VPWR VGND sg13cmos5l_nor2_1
XFILLER_36_160 VPWR VGND sg13cmos5l_decap_8
X_3008_ _3009_/B _3008_/A _3028_/B VPWR VGND sg13cmos5l_xnor2_1
XFILLER_15_377 VPWR VGND sg13cmos5l_fill_1
XFILLER_35_83 VPWR VGND sg13cmos5l_decap_8
XFILLER_42_152 VPWR VGND sg13cmos5l_decap_8
XFILLER_42_163 VPWR VGND sg13cmos5l_fill_2
X_2172_ _2512_/A _2351_/A _2280_/A VPWR VGND sg13cmos5l_nor2_1
X_2241_ _2242_/B _2446_/B _2446_/C _2493_/C VPWR VGND sg13cmos5l_a21o_1
X_2310_ _2310_/Y _2306_/Y _2308_/Y _2309_/Y VPWR VGND sg13cmos5l_o21ai_1
X_3290_ _3290_/Y _3293_/A _3290_/B VPWR VGND sg13cmos5l_nor2_1
XFILLER_18_182 VPWR VGND sg13cmos5l_fill_2
XFILLER_33_130 VPWR VGND sg13cmos5l_decap_8
XFILLER_21_336 VPWR VGND sg13cmos5l_decap_8
XFILLER_33_196 VPWR VGND sg13cmos5l_fill_2
X_1887_ _1908_/C _1852_/A _1886_/Y _2024_/A VPWR VGND sg13cmos5l_a21oi_1
X_1956_ _1957_/C _1938_/Y _1940_/Y _1955_/Y VPWR VGND sg13cmos5l_o21ai_1
X_2508_ _2554_/B _2508_/A _2508_/B VPWR VGND sg13cmos5l_nand2_1
X_2439_ _2441_/C _2439_/A _2523_/B _2454_/B _2447_/D VPWR VGND sg13cmos5l_nand4_1
XFILLER_12_369 VPWR VGND sg13cmos5l_decap_4
XFILLER_8_307 VPWR VGND sg13cmos5l_fill_2
XFILLER_46_60 VPWR VGND sg13cmos5l_fill_1
XFILLER_46_82 VPWR VGND sg13cmos5l_fill_1
XFILLER_7_32 VPWR VGND sg13cmos5l_fill_2
X_1741_ _1741_/X _2098_/A _2150_/B VPWR VGND sg13cmos5l_and2_1
X_1810_ _1810_/Y _1933_/B _3190_/B _1809_/Y VPWR VGND sg13cmos5l_o21ai_1
X_2790_ _2805_/B _3089_/A _3089_/B _3138_/A _2790_/D VPWR VGND sg13cmos5l_nor4_1
XFILLER_30_2 VPWR VGND sg13cmos5l_fill_1
X_1672_ _2971_/A _2972_/A VPWR VGND sg13cmos5l_inv_1
Xhold329 _2773_/A _3367_/Q VPWR VGND sg13cmos5l_dlygate4sd3_1
Xhold318 hold318/X _3398_/Q VPWR VGND sg13cmos5l_dlygate4sd3_1
Xhold307 _2913_/A _3407_/Q VPWR VGND sg13cmos5l_dlygate4sd3_1
X_3411_ _3411_/Q clkload6/A _3411_/D fanout184/X VPWR VGND sg13cmos5l_dfrbpq_1
X_3342_ _3342_/Q _3342_/CLK _3342_/D fanout181/X VPWR VGND sg13cmos5l_dfrbpq_1
X_2155_ _2392_/A _2499_/B _2267_/A VPWR VGND sg13cmos5l_nor2_1
X_2224_ _2227_/C _2432_/A _2224_/B _2224_/C VPWR VGND sg13cmos5l_nor3_1
X_3273_ _3321_/D _2832_/B _3272_/Y _3268_/Y VPWR VGND sg13cmos5l_o21ai_1
X_2086_ _2086_/X _2086_/A _2319_/B _2337_/B VPWR VGND sg13cmos5l_or3_1
XFILLER_21_166 VPWR VGND sg13cmos5l_fill_2
XFILLER_21_177 VPWR VGND sg13cmos5l_fill_2
X_1939_ _1940_/A _2653_/A _1937_/B _1834_/A _2665_/A1 VPWR VGND sg13cmos5l_a22oi_1
X_2988_ _2993_/D _2990_/B _3048_/A VPWR VGND sg13cmos5l_nor2_1
XFILLER_29_266 VPWR VGND sg13cmos5l_fill_2
XFILLER_12_177 VPWR VGND sg13cmos5l_fill_2
XFILLER_12_188 VPWR VGND sg13cmos5l_fill_2
XFILLER_32_84 VPWR VGND sg13cmos5l_decap_8
XFILLER_4_354 VPWR VGND sg13cmos5l_fill_1
X_2911_ _2911_/Y hold323/X _2910_/B _2907_/B VPWR VGND sg13cmos5l_o21ai_1
X_1724_ _1724_/X _3415_/Q _1724_/B VPWR VGND sg13cmos5l_or2_1
X_2842_ _2857_/C _3141_/B _2842_/B VPWR VGND sg13cmos5l_nor2_1
X_2773_ _2774_/B _2773_/A _3274_/B _2773_/C VPWR VGND sg13cmos5l_nand3_1
X_1655_ _2639_/A _2028_/A VPWR VGND sg13cmos5l_inv_1
X_3325_ _3325_/Q clkload3/A _3325_/D fanout174/X VPWR VGND sg13cmos5l_dfrbpq_1
X_3256_ _3258_/A _3256_/A1 _2092_/B _3254_/B _3254_/A _3255_/Y VPWR VGND sg13cmos5l_a221oi_1
XFILLER_37_29 VPWR VGND sg13cmos5l_decap_8
X_2069_ _2069_/Y _3208_/B _2069_/B VPWR VGND sg13cmos5l_nand2_1
X_2138_ _2138_/Y _3425_/Q _2139_/B VPWR VGND sg13cmos5l_nor2b_1
X_2207_ _2536_/A _2493_/B _2207_/B _2542_/B VPWR VGND sg13cmos5l_nand3_1
X_3187_ _3187_/Y _3247_/A1 _1866_/B _3186_/Y VPWR VGND sg13cmos5l_o21ai_1
Xclkbuf_5_13__f_clk clkload3/A clkbuf_4_6_0_clk/X VPWR VGND sg13cmos5l_buf_8
XFILLER_25_280 VPWR VGND sg13cmos5l_fill_2
XFILLER_25_291 VPWR VGND sg13cmos5l_fill_2
XFILLER_32_206 VPWR VGND sg13cmos5l_decap_8
Xheichips26_heiscore_200 uio_out[4] VPWR VGND sg13cmos5l_tielo
X_3110_ _3112_/A _3091_/A _1896_/X _3109_/X VPWR VGND sg13cmos5l_o21ai_1
X_3041_ _3042_/B _3041_/A _3041_/B VPWR VGND sg13cmos5l_xnor2_1
X_2825_ _2828_/B _3089_/B _2825_/B VPWR VGND sg13cmos5l_nor2_1
X_1707_ _3235_/A _3164_/C VPWR VGND sg13cmos5l_inv_1
X_2756_ _2756_/Y _2934_/B _2756_/B VPWR VGND sg13cmos5l_nor2_1
X_2687_ _2705_/B _3358_/Q _2693_/B VPWR VGND sg13cmos5l_nor2_1
XFILLER_48_28 VPWR VGND sg13cmos5l_decap_8
X_3308_ _3308_/Q _3335_/CLK _3308_/D fanout187/X VPWR VGND sg13cmos5l_dfrbpq_1
X_3239_ _3240_/B _1981_/B _1981_/C _3238_/Y VPWR VGND sg13cmos5l_a21oi_1
Xfanout21 _2740_/A _2934_/A VPWR VGND sg13cmos5l_buf_1
Xfanout32 _3026_/B _2191_/X VPWR VGND sg13cmos5l_buf_1
Xfanout43 _2380_/A _2415_/B VPWR VGND sg13cmos5l_buf_1
Xfanout54 _2248_/A _2099_/X VPWR VGND sg13cmos5l_buf_1
Xfanout65 _2932_/B _2913_/B VPWR VGND sg13cmos5l_buf_1
Xfanout76 _3265_/B hold378/X VPWR VGND sg13cmos5l_buf_1
Xfanout87 _3272_/A hold366/X VPWR VGND sg13cmos5l_buf_1
Xfanout98 _3145_/B _3054_/B VPWR VGND sg13cmos5l_buf_1
XFILLER_38_61 VPWR VGND sg13cmos5l_decap_8
X_2610_ _3332_/D _1965_/B _2676_/A2 _2591_/Y _2609_/Y VPWR VGND sg13cmos5l_a22oi_1
X_2541_ _2551_/C _2541_/A _2541_/B _2541_/C _2541_/D VPWR VGND sg13cmos5l_nand4_1
X_2472_ _2528_/A _2540_/A _2540_/B _3293_/A VPWR VGND sg13cmos5l_and3_1
XFILLER_36_331 VPWR VGND sg13cmos5l_fill_2
X_3024_ _3308_/D _3019_/A _3006_/B _3023_/Y VPWR VGND sg13cmos5l_a21o_1
X_2808_ _2808_/Y _2830_/A _2808_/B VPWR VGND sg13cmos5l_nand2b_1
X_2739_ _2740_/B _2734_/B _2167_/Y _2738_/X _3365_/Q VPWR VGND sg13cmos5l_a22oi_1
XFILLER_19_309 VPWR VGND sg13cmos5l_fill_2
XFILLER_6_246 VPWR VGND sg13cmos5l_fill_2
XFILLER_49_60 VPWR VGND sg13cmos5l_decap_8
XFILLER_18_331 VPWR VGND sg13cmos5l_decap_8
XFILLER_18_364 VPWR VGND sg13cmos5l_decap_8
XFILLER_18_397 VPWR VGND sg13cmos5l_decap_8
XFILLER_33_301 VPWR VGND sg13cmos5l_fill_1
XFILLER_37_139 VPWR VGND sg13cmos5l_decap_8
X_1972_ _2060_/C _1972_/A _1972_/B VPWR VGND sg13cmos5l_xnor2_1
XFILLER_46_0 VPWR VGND sg13cmos5l_decap_8
X_2524_ _2525_/D _2524_/A _2524_/B _2524_/C _2524_/D VPWR VGND sg13cmos5l_nor4_1
X_2455_ _2456_/D _2485_/C _2455_/B _2455_/C _2455_/D VPWR VGND sg13cmos5l_nor4_1
XFILLER_28_117 VPWR VGND sg13cmos5l_fill_2
XFILLER_45_18 VPWR VGND sg13cmos5l_fill_1
X_2386_ _2387_/B _2428_/C _2677_/B _2430_/C VPWR VGND sg13cmos5l_nand3_1
XFILLER_24_323 VPWR VGND sg13cmos5l_decap_8
XFILLER_36_194 VPWR VGND sg13cmos5l_fill_1
X_3007_ _3009_/A _1669_/A _3001_/X _3002_/A VPWR VGND sg13cmos5l_a21oi_1
XFILLER_3_216 VPWR VGND sg13cmos5l_fill_2
XFILLER_15_334 VPWR VGND sg13cmos5l_decap_8
XFILLER_35_40 VPWR VGND sg13cmos5l_decap_8
XFILLER_35_73 VPWR VGND sg13cmos5l_decap_4
XFILLER_42_131 VPWR VGND sg13cmos5l_decap_8
X_2171_ _2251_/A _1662_/Y _2728_/A _2166_/Y VPWR VGND sg13cmos5l_a21oi_1
X_2240_ _2493_/C _2240_/A _2369_/A VPWR VGND sg13cmos5l_nand2_1
X_1886_ _1886_/Y _2076_/A _1886_/B VPWR VGND sg13cmos5l_nand2_1
X_1955_ _1955_/Y _1955_/A _1955_/B _1955_/C _1955_/D VPWR VGND sg13cmos5l_nor4_1
X_2507_ _2508_/B _2133_/X _2205_/B _2370_/A VPWR VGND sg13cmos5l_o21ai_1
X_2438_ _2447_/D _2438_/A _2438_/B VPWR VGND sg13cmos5l_nand2_1
X_2369_ _2476_/C _2369_/A _2380_/A _2369_/C VPWR VGND sg13cmos5l_nand3_1
XFILLER_24_164 VPWR VGND sg13cmos5l_fill_2
X_1671_ _2941_/B _3115_/A VPWR VGND sg13cmos5l_inv_1
X_1740_ _2150_/B _3427_/Q _3425_/Q VPWR VGND sg13cmos5l_nor2b_1
Xhold308 hold308/X _2913_/Y VPWR VGND sg13cmos5l_dlygate4sd3_1
Xhold319 _2878_/A _3394_/Q VPWR VGND sg13cmos5l_dlygate4sd3_1
X_3410_ _3410_/Q _3410_/CLK _3410_/D fanout184/X VPWR VGND sg13cmos5l_dfrbpq_1
X_3341_ _3341_/Q _3427_/CLK _3341_/D fanout181/X VPWR VGND sg13cmos5l_dfrbpq_1
X_3272_ _3272_/Y _3272_/A _3272_/B _3272_/C _3272_/D VPWR VGND sg13cmos5l_nor4_1
XFILLER_38_278 VPWR VGND sg13cmos5l_fill_2
X_2085_ _2296_/B _2085_/A _2085_/B VPWR VGND sg13cmos5l_xnor2_1
X_2154_ _2267_/A _2433_/A _2196_/A _2153_/Y VPWR VGND sg13cmos5l_o21ai_1
X_2223_ _2224_/C _2410_/C _2275_/B _2935_/C _2223_/D VPWR VGND sg13cmos5l_nand4_1
X_2987_ _3303_/D _2987_/A VPWR VGND sg13cmos5l_inv_1
X_1869_ _1869_/Y _3116_/A _1823_/B _1863_/Y _1868_/X _1866_/Y VPWR VGND sg13cmos5l_a221oi_1
X_1938_ _1938_/Y _2646_/A _3058_/B _1932_/X _1936_/Y _1937_/Y VPWR VGND sg13cmos5l_a221oi_1
XFILLER_44_226 VPWR VGND sg13cmos5l_fill_1
XFILLER_32_41 VPWR VGND sg13cmos5l_decap_8
XFILLER_35_215 VPWR VGND sg13cmos5l_decap_4
X_2910_ _2910_/Y _3406_/Q _2910_/B VPWR VGND sg13cmos5l_nor2_1
X_2841_ _2841_/Y _2782_/B _2838_/A _2840_/Y VPWR VGND sg13cmos5l_a21oi_1
X_1654_ _2286_/A _2007_/A VPWR VGND sg13cmos5l_inv_1
X_1723_ _1736_/B _3419_/D _3417_/D VPWR VGND sg13cmos5l_nor2_1
X_2772_ _3366_/D _2375_/A _2684_/B _2361_/A VPWR VGND sg13cmos5l_a21o_1
X_2206_ _2542_/B _2206_/A _2238_/D VPWR VGND sg13cmos5l_nand2_1
X_3324_ _3324_/Q _3360_/CLK _3324_/D fanout168/X VPWR VGND sg13cmos5l_dfrbpq_1
X_3255_ _3255_/Y _3115_/B _2082_/Y _3252_/Y _3253_/Y _3254_/Y VPWR VGND sg13cmos5l_a221oi_1
XFILLER_26_237 VPWR VGND sg13cmos5l_decap_8
X_2068_ _2069_/B _2068_/A _2068_/B VPWR VGND sg13cmos5l_xnor2_1
X_2137_ _2196_/A _2213_/A _2158_/B VPWR VGND sg13cmos5l_nand2b_1
X_3186_ _3186_/Y _3181_/Y _3184_/Y _3185_/Y VPWR VGND sg13cmos5l_o21ai_1
XFILLER_27_85 VPWR VGND sg13cmos5l_decap_4
XFILLER_32_229 VPWR VGND sg13cmos5l_decap_8
XFILLER_43_73 VPWR VGND sg13cmos5l_fill_1
Xheichips26_heiscore_201 uio_out[5] VPWR VGND sg13cmos5l_tielo
X_3040_ _3042_/A _3032_/A _3041_/B _3035_/Y VPWR VGND sg13cmos5l_a21oi_1
X_2824_ _2825_/B _2827_/A _2826_/B VPWR VGND sg13cmos5l_nor2_1
X_1706_ _3265_/A _3156_/A VPWR VGND sg13cmos5l_inv_1
X_2755_ _2756_/B _2755_/A _2755_/B VPWR VGND sg13cmos5l_xnor2_1
X_2686_ _2686_/Y _2678_/Y _2683_/Y _2757_/A2 _1685_/Y VPWR VGND sg13cmos5l_a22oi_1
X_3307_ _3307_/Q _3307_/CLK _3307_/D fanout182/X VPWR VGND sg13cmos5l_dfrbpq_1
X_3238_ _3238_/Y _2002_/A _1981_/C _1965_/B VPWR VGND sg13cmos5l_a21oi_1
X_3169_ _3169_/Y _3175_/B _3169_/B VPWR VGND sg13cmos5l_nand2_1
XFILLER_22_251 VPWR VGND sg13cmos5l_fill_1
Xfanout22 _3006_/B _3039_/B VPWR VGND sg13cmos5l_buf_1
Xfanout33 _2369_/C _2251_/A VPWR VGND sg13cmos5l_buf_1
Xfanout44 _2363_/B _2415_/B VPWR VGND sg13cmos5l_buf_1
Xfanout55 _2557_/B1 _2401_/B VPWR VGND sg13cmos5l_buf_1
XFILLER_22_284 VPWR VGND sg13cmos5l_fill_2
Xfanout66 _3288_/B _2606_/B VPWR VGND sg13cmos5l_buf_1
Xfanout77 _3164_/C hold365/X VPWR VGND sg13cmos5l_buf_1
Xfanout88 _3256_/A1 _3379_/Q VPWR VGND sg13cmos5l_buf_1
Xfanout99 _3054_/B _3374_/Q VPWR VGND sg13cmos5l_buf_1
XFILLER_38_84 VPWR VGND sg13cmos5l_decap_4
XFILLER_9_222 VPWR VGND sg13cmos5l_decap_8
XFILLER_9_277 VPWR VGND sg13cmos5l_fill_1
X_2540_ _2555_/D _2540_/A _2540_/B _2540_/C VPWR VGND sg13cmos5l_nand3_1
X_2471_ _2547_/B _2198_/B _2450_/B _2370_/A VPWR VGND sg13cmos5l_o21ai_1
X_3023_ _3023_/Y _3023_/A _3023_/B _3023_/C VPWR VGND sg13cmos5l_nor3_1
X_2807_ _2808_/B _2807_/A _2807_/B VPWR VGND sg13cmos5l_or2_1
X_2738_ _2738_/X _2763_/A _2738_/B VPWR VGND sg13cmos5l_or2_1
X_2669_ _2670_/B _2668_/A _2668_/B _2656_/A VPWR VGND sg13cmos5l_o21ai_1
XFILLER_6_269 VPWR VGND sg13cmos5l_fill_1
X_1971_ _1974_/A _1999_/B _1972_/B VPWR VGND sg13cmos5l_xnor2_1
XFILLER_39_0 VPWR VGND sg13cmos5l_decap_8
X_2523_ _2524_/D _2523_/A _2523_/B _2560_/A _2541_/C VPWR VGND sg13cmos5l_nand4_1
X_2454_ _2455_/D _2454_/A _2454_/B _2454_/C VPWR VGND sg13cmos5l_nand3_1
X_2385_ _2430_/C _2498_/A _2559_/B VPWR VGND sg13cmos5l_nor2_1
Xinput1 input1/X rst_n VPWR VGND sg13cmos5l_buf_1
X_3006_ _3006_/Y _3008_/A _3006_/B VPWR VGND sg13cmos5l_nand2_1
XFILLER_10_55 VPWR VGND sg13cmos5l_fill_2
XFILLER_3_206 VPWR VGND sg13cmos5l_fill_1
XFILLER_27_184 VPWR VGND sg13cmos5l_decap_8
XFILLER_42_110 VPWR VGND sg13cmos5l_decap_8
XFILLER_42_198 VPWR VGND sg13cmos5l_decap_4
X_2170_ _2170_/Y _2734_/B _2769_/B VPWR VGND sg13cmos5l_nor2b_1
XFILLER_33_143 VPWR VGND sg13cmos5l_decap_8
XFILLER_33_198 VPWR VGND sg13cmos5l_fill_1
X_1954_ _1955_/D _2665_/A1 _1834_/A _1853_/A VPWR VGND sg13cmos5l_o21ai_1
X_1885_ _1908_/B _1885_/A _2064_/C _1885_/C VPWR VGND sg13cmos5l_nand3_1
X_2506_ _2550_/A _2506_/A _2506_/B _2506_/C _2506_/D VPWR VGND sg13cmos5l_nor4_1
X_2437_ _2454_/B _2437_/A _2506_/C VPWR VGND sg13cmos5l_nor2_1
X_2368_ _2373_/B _2543_/A _2535_/A _2399_/B _2500_/B VPWR VGND sg13cmos5l_nand4_1
X_2299_ _2299_/Y _2282_/X _2297_/Y _2298_/Y VPWR VGND sg13cmos5l_o21ai_1
XFILLER_24_154 VPWR VGND sg13cmos5l_fill_2
XFILLER_47_213 VPWR VGND sg13cmos5l_fill_2
XFILLER_30_113 VPWR VGND sg13cmos5l_decap_8
XFILLER_46_73 VPWR VGND sg13cmos5l_decap_4
Xclkbuf_5_0__f_clk _3365_/CLK clkbuf_4_0_0_clk/X VPWR VGND sg13cmos5l_buf_8
XFILLER_11_360 VPWR VGND sg13cmos5l_fill_2
X_1670_ _2941_/A _2984_/A VPWR VGND sg13cmos5l_inv_1
Xhold309 _3407_/D _2915_/Y VPWR VGND sg13cmos5l_dlygate4sd3_1
X_2222_ _2223_/D _2557_/B1 _2415_/A _2380_/A _2179_/B _2219_/Y VPWR VGND sg13cmos5l_a221oi_1
X_3340_ _3340_/Q _3427_/CLK _3340_/D fanout182/X VPWR VGND sg13cmos5l_dfrbpq_1
X_3271_ _3272_/D _3269_/Y _3270_/Y _2826_/B VPWR VGND sg13cmos5l_a21oi_1
X_2084_ _2326_/B _2084_/A _2315_/B VPWR VGND sg13cmos5l_xnor2_1
X_2153_ _2153_/Y _2205_/B _2380_/A _2192_/B VPWR VGND sg13cmos5l_nand3_1
X_1937_ _1937_/Y _1937_/A _1937_/B VPWR VGND sg13cmos5l_nor2_1
X_2986_ _2987_/A _2984_/A _2950_/B _2980_/A _2985_/Y VPWR VGND sg13cmos5l_a22oi_1
X_1799_ _2302_/B _3055_/A _3014_/A _3066_/A VPWR VGND sg13cmos5l_o21ai_1
X_1868_ _1868_/X _1864_/Y _1865_/Y _1867_/Y VPWR VGND sg13cmos5l_a21o_1
XFILLER_20_190 VPWR VGND sg13cmos5l_decap_4
X_2840_ _2840_/Y _2838_/A _2852_/B _2782_/B VPWR VGND sg13cmos5l_a21oi_1
X_2771_ _2771_/Y _2768_/Y _2770_/Y _2767_/Y VPWR VGND sg13cmos5l_o21ai_1
X_1653_ _2077_/A _2076_/A VPWR VGND sg13cmos5l_inv_1
X_1722_ _2774_/A _2446_/A _2438_/A VPWR VGND sg13cmos5l_nand2_1
X_2205_ _2207_/B _2265_/B _2205_/B VPWR VGND sg13cmos5l_nand2_1
X_3323_ _3323_/Q _3419_/CLK _3323_/D fanout172/X VPWR VGND sg13cmos5l_dfrbpq_1
X_3254_ _3254_/Y _3254_/A _3254_/B VPWR VGND sg13cmos5l_nor2_1
X_3185_ _3185_/Y _3247_/A1 _1866_/B _1817_/X _3048_/B VPWR VGND sg13cmos5l_a22oi_1
X_2067_ _2067_/Y _3204_/B _2067_/B VPWR VGND sg13cmos5l_nor2_1
X_2136_ _2136_/Y _2213_/A _2157_/B VPWR VGND sg13cmos5l_nor2_1
X_2969_ _3300_/D _2969_/A VPWR VGND sg13cmos5l_inv_1
XFILLER_17_216 VPWR VGND sg13cmos5l_decap_4
XFILLER_27_75 VPWR VGND sg13cmos5l_fill_1
XFILLER_25_260 VPWR VGND sg13cmos5l_decap_8
XFILLER_25_271 VPWR VGND sg13cmos5l_fill_1
XFILLER_25_293 VPWR VGND sg13cmos5l_fill_1
XFILLER_43_52 VPWR VGND sg13cmos5l_decap_8
XFILLER_43_96 VPWR VGND sg13cmos5l_decap_8
Xheichips26_heiscore_202 uio_out[6] VPWR VGND sg13cmos5l_tielo
XFILLER_0_370 VPWR VGND sg13cmos5l_fill_1
XFILLER_16_293 VPWR VGND sg13cmos5l_decap_8
XFILLER_31_241 VPWR VGND sg13cmos5l_fill_2
XFILLER_31_285 VPWR VGND sg13cmos5l_fill_2
X_1705_ _3146_/A _3145_/B VPWR VGND sg13cmos5l_inv_1
X_2823_ _2826_/B _3089_/A _3138_/A _3137_/A VPWR VGND sg13cmos5l_nand3_1
X_2754_ _2754_/X hold266/X _2757_/A2 _2753_/Y VPWR VGND sg13cmos5l_a21o_1
X_3306_ _3306_/Q _3307_/CLK _3306_/D fanout182/X VPWR VGND sg13cmos5l_dfrbpq_1
X_2685_ _2685_/Y _2792_/B _2751_/A _2712_/C VPWR VGND sg13cmos5l_nor3_1
X_2119_ _2280_/A _2147_/B _2142_/B VPWR VGND sg13cmos5l_nand2b_1
X_3237_ _3242_/A _3233_/Y _3234_/Y _3236_/Y VPWR VGND sg13cmos5l_o21ai_1
X_3168_ _3169_/B _3168_/A _3208_/A _3168_/C VPWR VGND sg13cmos5l_nor3_1
Xfanout23 _2950_/B _2942_/Y VPWR VGND sg13cmos5l_buf_1
Xfanout34 _3254_/B _2079_/Y VPWR VGND sg13cmos5l_buf_1
Xfanout45 _2415_/B _2149_/Y VPWR VGND sg13cmos5l_buf_1
Xfanout56 _2401_/B _2438_/B VPWR VGND sg13cmos5l_buf_1
Xfanout67 _2606_/B _2612_/B VPWR VGND sg13cmos5l_buf_1
Xfanout78 _3164_/D _3386_/Q VPWR VGND sg13cmos5l_buf_1
Xfanout89 _3089_/B hold364/X VPWR VGND sg13cmos5l_buf_1
X_3099_ _3100_/C _3101_/B _3144_/C VPWR VGND sg13cmos5l_nor2b_1
XFILLER_13_44 VPWR VGND sg13cmos5l_fill_1
XFILLER_49_116 VPWR VGND sg13cmos5l_decap_8
XFILLER_13_285 VPWR VGND sg13cmos5l_fill_1
XFILLER_9_289 VPWR VGND sg13cmos5l_fill_1
X_2470_ _2547_/A _2250_/A _2450_/B _2446_/A VPWR VGND sg13cmos5l_o21ai_1
X_3022_ _3023_/C _3022_/A _3021_/A VPWR VGND sg13cmos5l_nor2b_1
X_2806_ _2830_/A _2806_/A _2806_/B VPWR VGND sg13cmos5l_nor2_1
X_2737_ _3353_/D _1682_/Y _2767_/B _2713_/Y _2736_/X VPWR VGND sg13cmos5l_a22oi_1
X_2668_ _2670_/A _2668_/A _2668_/B VPWR VGND sg13cmos5l_and2_1
X_2599_ _2599_/Y _2062_/A _2606_/B _2597_/B VPWR VGND sg13cmos5l_o21ai_1
XFILLER_39_193 VPWR VGND sg13cmos5l_decap_8
XFILLER_46_119 VPWR VGND sg13cmos5l_decap_8
XFILLER_40_97 VPWR VGND sg13cmos5l_decap_8
XFILLER_18_300 VPWR VGND sg13cmos5l_fill_1
XFILLER_1_58 VPWR VGND sg13cmos5l_fill_2
XFILLER_49_95 VPWR VGND sg13cmos5l_decap_8
X_1970_ _1980_/C _3233_/B _1970_/B VPWR VGND sg13cmos5l_nand2_1
X_2522_ _2524_/C _2522_/A _2522_/B _2522_/C _2540_/C VPWR VGND sg13cmos5l_nand4_1
X_2453_ _2454_/C _2516_/A _2520_/C _2453_/C VPWR VGND sg13cmos5l_nor3_1
X_2384_ _2559_/B _2351_/B _2195_/B _2433_/A VPWR VGND sg13cmos5l_a21oi_1
XFILLER_36_174 VPWR VGND sg13cmos5l_fill_2
Xinput2 input2/X ui_in[0] VPWR VGND sg13cmos5l_buf_1
X_3005_ _3305_/D _3005_/A VPWR VGND sg13cmos5l_inv_1
XFILLER_3_218 VPWR VGND sg13cmos5l_fill_1
XFILLER_19_76 VPWR VGND sg13cmos5l_fill_2
XFILLER_27_163 VPWR VGND sg13cmos5l_decap_8
XFILLER_35_97 VPWR VGND sg13cmos5l_decap_4
Xclkbuf_5_19__f_clk _3427_/CLK clkbuf_4_9_0_clk/X VPWR VGND sg13cmos5l_buf_8
XFILLER_33_155 VPWR VGND sg13cmos5l_decap_8
X_1884_ _1885_/C _2049_/A _2593_/A VPWR VGND sg13cmos5l_nor2b_1
X_1953_ _1957_/B _1955_/A _1955_/B _1853_/A VPWR VGND sg13cmos5l_o21ai_1
X_2505_ _2506_/D _2351_/B _2208_/A _2270_/A VPWR VGND sg13cmos5l_a21oi_1
X_2298_ _2298_/Y _2302_/A _2082_/Y _2296_/Y VPWR VGND sg13cmos5l_a21oi_1
X_2436_ _2506_/C _2436_/A _2436_/B VPWR VGND sg13cmos5l_nor2_1
X_2367_ _2559_/A _2500_/B VPWR VGND sg13cmos5l_inv_1
XFILLER_12_306 VPWR VGND sg13cmos5l_fill_1
XFILLER_24_133 VPWR VGND sg13cmos5l_decap_8
XFILLER_12_339 VPWR VGND sg13cmos5l_decap_8
XFILLER_46_30 VPWR VGND sg13cmos5l_fill_2
XFILLER_30_103 VPWR VGND sg13cmos5l_decap_4
X_2152_ _2192_/B input2/X input3/X input4/X input5/X VPWR VGND sg13cmos5l_nor4_1
X_2221_ _2935_/C input4/X _2269_/C VPWR VGND sg13cmos5l_nand2_1
X_3270_ _3270_/Y _3144_/A _3144_/C _3138_/B VPWR VGND sg13cmos5l_a21oi_1
X_2083_ _2319_/B _2646_/A _2315_/B VPWR VGND sg13cmos5l_xnor2_1
X_1867_ _1867_/Y _1865_/B _1865_/C _2010_/A VPWR VGND sg13cmos5l_a21oi_1
X_1936_ _1936_/Y _1934_/A _2307_/A _1935_/A _1935_/B VPWR VGND sg13cmos5l_a22oi_1
X_2985_ _2985_/Y _2985_/A _2985_/B VPWR VGND sg13cmos5l_xnor2_1
X_1798_ _1905_/B _2077_/A _1852_/A VPWR VGND sg13cmos5l_xnor2_1
X_3399_ _3399_/Q _3402_/CLK _3399_/D fanout183/X VPWR VGND sg13cmos5l_dfrbpq_1
X_2419_ _2420_/B _2419_/A _2429_/B _2506_/B _2419_/D VPWR VGND sg13cmos5l_nor4_1
XFILLER_32_98 VPWR VGND sg13cmos5l_fill_2
X_1721_ _1721_/Y _2274_/C _2184_/A VPWR VGND sg13cmos5l_nor2_1
X_2770_ _2770_/Y _2770_/A _2770_/B VPWR VGND sg13cmos5l_nand2_1
X_1652_ _2085_/A _1937_/A VPWR VGND sg13cmos5l_inv_1
X_3322_ _3322_/Q _3423_/CLK _3322_/D fanout181/X VPWR VGND sg13cmos5l_dfrbpq_1
XFILLER_26_206 VPWR VGND sg13cmos5l_decap_8
X_2135_ _2522_/A _2206_/A _2412_/B _2450_/B _2557_/B1 VPWR VGND sg13cmos5l_a22oi_1
X_2204_ _2493_/B _2557_/B1 _2265_/A _2179_/B _2412_/A VPWR VGND sg13cmos5l_a22oi_1
X_3253_ _3253_/Y _3253_/A1 _2086_/A _2337_/B _3180_/A VPWR VGND sg13cmos5l_a22oi_1
X_3184_ _3184_/Y _3048_/B _1817_/X _3183_/Y VPWR VGND sg13cmos5l_o21ai_1
XFILLER_41_209 VPWR VGND sg13cmos5l_fill_2
X_2066_ _2067_/B _2575_/A _2066_/B VPWR VGND sg13cmos5l_xnor2_1
X_1919_ _2158_/B _3421_/Q _3422_/Q VPWR VGND sg13cmos5l_nor2b_1
X_2968_ _2969_/A _2963_/A _2950_/B _2980_/A _2967_/Y VPWR VGND sg13cmos5l_a22oi_1
X_2899_ _2908_/D _3401_/Q _2899_/B _2899_/C VPWR VGND sg13cmos5l_or3_1
XFILLER_13_401 VPWR VGND sg13cmos5l_fill_2
Xheichips26_heiscore_203 uio_out[7] VPWR VGND sg13cmos5l_tielo
XFILLER_16_272 VPWR VGND sg13cmos5l_decap_8
X_1704_ _2807_/A _3144_/A VPWR VGND sg13cmos5l_inv_1
X_2822_ _2822_/Y _3253_/A1 _2821_/C _2821_/Y VPWR VGND sg13cmos5l_o21ai_1
X_2753_ _2753_/Y _2934_/B _2753_/B VPWR VGND sg13cmos5l_nor2_1
X_2684_ _2712_/C _2677_/Y _2684_/B VPWR VGND sg13cmos5l_nand2b_1
X_3305_ _3305_/Q _3307_/CLK _3305_/D fanout182/X VPWR VGND sg13cmos5l_dfrbpq_1
X_2049_ _2051_/D _2049_/A _2049_/B VPWR VGND sg13cmos5l_nand2_1
X_2118_ _2250_/A _2147_/B _2142_/B VPWR VGND sg13cmos5l_nor2b_1
X_3236_ _3236_/Y _3386_/Q _3233_/B _3235_/Y VPWR VGND sg13cmos5l_a21oi_1
X_3167_ _3167_/Y _3348_/Q _3167_/B _3167_/C VPWR VGND sg13cmos5l_nand3_1
X_3098_ _3106_/A _3098_/A _3145_/B VPWR VGND sg13cmos5l_xor2_1
XFILLER_22_242 VPWR VGND sg13cmos5l_decap_8
Xfanout24 _2852_/B _2821_/B VPWR VGND sg13cmos5l_buf_1
Xfanout35 _3276_/B _1733_/Y VPWR VGND sg13cmos5l_buf_1
Xfanout46 _2265_/B _2138_/Y VPWR VGND sg13cmos5l_buf_1
Xfanout57 _2315_/B _2294_/B VPWR VGND sg13cmos5l_buf_1
Xfanout68 _1865_/B _1781_/B VPWR VGND sg13cmos5l_buf_1
Xfanout79 _3208_/A _3124_/A VPWR VGND sg13cmos5l_buf_1
XFILLER_13_220 VPWR VGND sg13cmos5l_decap_8
XFILLER_13_231 VPWR VGND sg13cmos5l_fill_1
XFILLER_13_242 VPWR VGND sg13cmos5l_fill_2
XFILLER_13_297 VPWR VGND sg13cmos5l_fill_2
XFILLER_9_268 VPWR VGND sg13cmos5l_decap_8
X_3021_ _3023_/B _3021_/A _3022_/A VPWR VGND sg13cmos5l_nor2b_1
X_2805_ _2806_/B _2832_/B _2805_/B VPWR VGND sg13cmos5l_nor2_1
X_2736_ _2736_/X _2740_/A _2736_/B _2736_/C VPWR VGND sg13cmos5l_or3_1
X_2667_ _2668_/B _2667_/A _2667_/B VPWR VGND sg13cmos5l_xnor2_1
X_3219_ _3219_/Y _3219_/A VPWR VGND sg13cmos5l_inv_1
X_2598_ _3330_/D _2062_/A _3294_/A2 _2591_/Y _2597_/Y VPWR VGND sg13cmos5l_a22oi_1
XFILLER_39_172 VPWR VGND sg13cmos5l_decap_8
XFILLER_10_201 VPWR VGND sg13cmos5l_fill_1
XFILLER_10_245 VPWR VGND sg13cmos5l_fill_1
XFILLER_40_54 VPWR VGND sg13cmos5l_decap_8
XFILLER_6_216 VPWR VGND sg13cmos5l_fill_2
Xhold290 _2919_/A _3409_/Q VPWR VGND sg13cmos5l_dlygate4sd3_1
XFILLER_49_74 VPWR VGND sg13cmos5l_decap_8
X_2521_ _2525_/C _2446_/A _2363_/A _2363_/B _2198_/B _2555_/B VPWR VGND sg13cmos5l_a221oi_1
X_2452_ _2453_/C _2270_/A _2433_/B _2541_/A VPWR VGND sg13cmos5l_o21ai_1
X_2383_ _2498_/A _2412_/A _2415_/A VPWR VGND sg13cmos5l_and2_1
XFILLER_36_153 VPWR VGND sg13cmos5l_decap_8
Xinput3 input3/X ui_in[1] VPWR VGND sg13cmos5l_buf_1
X_3004_ _3004_/Y hold288/X _3006_/B _2997_/Y _3003_/Y VPWR VGND sg13cmos5l_a22oi_1
X_2719_ _2720_/D _3363_/Q _2734_/B _2722_/B VPWR VGND sg13cmos5l_nor3_1
XFILLER_35_21 VPWR VGND sg13cmos5l_fill_1
XFILLER_35_54 VPWR VGND sg13cmos5l_fill_2
XFILLER_42_145 VPWR VGND sg13cmos5l_decap_8
XFILLER_2_274 VPWR VGND sg13cmos5l_fill_2
XFILLER_18_197 VPWR VGND sg13cmos5l_decap_4
XFILLER_33_123 VPWR VGND sg13cmos5l_decap_8
XFILLER_33_189 VPWR VGND sg13cmos5l_decap_8
X_1883_ _2064_/C _2037_/A _1999_/B VPWR VGND sg13cmos5l_nand2_1
X_1952_ _1957_/A _1949_/Y _1950_/Y _1951_/Y VPWR VGND sg13cmos5l_o21ai_1
XFILLER_44_0 VPWR VGND sg13cmos5l_decap_8
X_2504_ _2535_/D _2369_/A _2450_/B _2415_/B VPWR VGND sg13cmos5l_o21ai_1
X_2435_ _2437_/A _2435_/A _2435_/B VPWR VGND sg13cmos5l_nor2_1
X_2297_ _2297_/Y _1933_/B _2326_/B _2293_/X _2295_/Y VPWR VGND sg13cmos5l_a22oi_1
Xclkbuf_5_25__f_clk clkload6/A clkbuf_4_12_0_clk/X VPWR VGND sg13cmos5l_buf_8
X_2366_ _2500_/B _2446_/A _2412_/B _2245_/B _2248_/A VPWR VGND sg13cmos5l_a22oi_1
XFILLER_46_53 VPWR VGND sg13cmos5l_decap_8
XFILLER_11_362 VPWR VGND sg13cmos5l_fill_1
X_2082_ _2082_/Y _2086_/A VPWR VGND sg13cmos5l_inv_1
X_2151_ _2558_/A _2205_/B _2380_/A VPWR VGND sg13cmos5l_nand2_1
X_2220_ _2220_/X input4/X _2269_/C VPWR VGND sg13cmos5l_and2_1
XFILLER_46_292 VPWR VGND sg13cmos5l_fill_1
X_2984_ _2985_/B _2984_/A _2984_/B VPWR VGND sg13cmos5l_xnor2_1
XFILLER_21_148 VPWR VGND sg13cmos5l_decap_4
X_1797_ _1797_/Y _2076_/A _1852_/A VPWR VGND sg13cmos5l_xnor2_1
X_1866_ _1866_/Y _3298_/Q _1866_/B VPWR VGND sg13cmos5l_nor2_1
X_1935_ _1945_/C _1935_/A _1935_/B VPWR VGND sg13cmos5l_nand2_1
X_3398_ _3398_/Q _3402_/CLK _3398_/D fanout183/X VPWR VGND sg13cmos5l_dfrbpq_1
X_2418_ _2419_/D _2418_/A _2535_/A _2518_/B _2418_/D VPWR VGND sg13cmos5l_nand4_1
XFILLER_29_259 VPWR VGND sg13cmos5l_decap_8
X_2349_ _2350_/C _2485_/B _2457_/A _2349_/C _2349_/D VPWR VGND sg13cmos5l_nor4_1
XFILLER_32_77 VPWR VGND sg13cmos5l_decap_8
XFILLER_35_207 VPWR VGND sg13cmos5l_fill_2
X_1651_ _1651_/Y _1934_/A VPWR VGND sg13cmos5l_inv_1
X_1720_ _2184_/A _3423_/Q _3424_/Q _2178_/A VPWR VGND sg13cmos5l_nand3_1
X_3321_ _3450_/A _3364_/CLK _3321_/D fanout163/X VPWR VGND sg13cmos5l_dfrbpq_1
X_3252_ _3252_/Y _3180_/A _2337_/B _3251_/Y VPWR VGND sg13cmos5l_o21ai_1
X_2065_ _2072_/C _2063_/Y _2064_/Y _1885_/A VPWR VGND sg13cmos5l_a21oi_1
X_2134_ _2435_/A _2178_/A _2134_/B VPWR VGND sg13cmos5l_nand2_1
X_2203_ _2410_/C _2216_/A _2206_/A _2462_/A VPWR VGND sg13cmos5l_a21oi_1
X_3183_ _3183_/Y _2322_/A _3183_/B VPWR VGND sg13cmos5l_nand2b_1
XFILLER_34_295 VPWR VGND sg13cmos5l_fill_2
X_2967_ _2967_/Y _2967_/A _2966_/Y VPWR VGND sg13cmos5l_nor2b_1
X_1849_ _2314_/A _2573_/A _1849_/B _2060_/A _1849_/D VPWR VGND sg13cmos5l_and4_1
X_1918_ _3275_/A _3274_/A _2413_/A _2197_/B _1918_/D VPWR VGND sg13cmos5l_or4_1
X_2898_ _2898_/Y _2899_/B _2907_/B VPWR VGND sg13cmos5l_nand2_1
XFILLER_27_33 VPWR VGND sg13cmos5l_fill_1
XFILLER_0_361 VPWR VGND sg13cmos5l_fill_1
XFILLER_31_243 VPWR VGND sg13cmos5l_fill_1
X_2821_ _2821_/Y _3089_/A _2821_/B _2821_/C VPWR VGND sg13cmos5l_nand3_1
X_1703_ _3190_/A _3137_/A VPWR VGND sg13cmos5l_inv_1
X_2752_ _3358_/D _2680_/A _2757_/A2 _2751_/X VPWR VGND sg13cmos5l_a21o_1
X_2683_ _2683_/Y _2694_/A _2751_/A _2703_/B _2710_/B VPWR VGND sg13cmos5l_nand4_1
X_3304_ _3304_/Q _3307_/CLK _3304_/D fanout182/X VPWR VGND sg13cmos5l_dfrbpq_1
X_3235_ _3235_/Y _3235_/A _3235_/B VPWR VGND sg13cmos5l_nor2_1
XFILLER_39_354 VPWR VGND sg13cmos5l_fill_2
XFILLER_39_376 VPWR VGND sg13cmos5l_fill_1
X_2048_ _3212_/B _2054_/B _2048_/B VPWR VGND sg13cmos5l_nand2_1
X_2117_ _2538_/A _2248_/B _2117_/B VPWR VGND sg13cmos5l_nor2_1
X_3166_ _3166_/Y _3349_/Q _3166_/B VPWR VGND sg13cmos5l_nand2_1
X_3097_ _3097_/Y _2941_/A _3089_/B _3256_/A1 VPWR VGND sg13cmos5l_a21oi_1
Xfanout14 _2757_/A2 _2685_/Y VPWR VGND sg13cmos5l_buf_1
Xfanout25 _3293_/A _2375_/Y VPWR VGND sg13cmos5l_buf_1
Xfanout36 _3274_/B _1733_/Y VPWR VGND sg13cmos5l_buf_1
Xfanout47 _2370_/A _2138_/Y VPWR VGND sg13cmos5l_buf_1
Xfanout58 _2351_/A _1742_/Y VPWR VGND sg13cmos5l_buf_1
Xfanout69 _2289_/B _1753_/Y VPWR VGND sg13cmos5l_buf_1
XFILLER_38_54 VPWR VGND sg13cmos5l_decap_8
XFILLER_48_7 VPWR VGND sg13cmos5l_decap_4
Xclkbuf_5_6__f_clk _3327_/CLK clkbuf_4_3_0_clk/X VPWR VGND sg13cmos5l_buf_8
XFILLER_48_151 VPWR VGND sg13cmos5l_fill_1
X_3020_ _3022_/A _3016_/A _3013_/Y _3014_/Y VPWR VGND sg13cmos5l_a21oi_1
X_2804_ _3372_/D _2844_/B _2804_/B VPWR VGND sg13cmos5l_nor2_1
X_2735_ _2736_/C _2734_/B _2725_/Y _2734_/Y VPWR VGND sg13cmos5l_o21ai_1
X_2666_ _2668_/A _2666_/A _2666_/B _2666_/C VPWR VGND sg13cmos5l_nand3_1
X_2597_ _2597_/Y _3286_/A _2597_/B _2597_/C VPWR VGND sg13cmos5l_nand3_1
XFILLER_39_151 VPWR VGND sg13cmos5l_decap_8
X_3218_ _3219_/A _3389_/Q _1989_/B _3263_/B VPWR VGND sg13cmos5l_o21ai_1
X_3149_ _3167_/C _3136_/B _3171_/B _3129_/Y VPWR VGND sg13cmos5l_o21ai_1
XFILLER_40_11 VPWR VGND sg13cmos5l_fill_2
XFILLER_49_53 VPWR VGND sg13cmos5l_decap_8
Xhold280 hold280/X _2904_/Y VPWR VGND sg13cmos5l_dlygate4sd3_1
Xhold291 _3409_/D _2921_/Y VPWR VGND sg13cmos5l_dlygate4sd3_1
XFILLER_18_357 VPWR VGND sg13cmos5l_decap_8
XFILLER_45_198 VPWR VGND sg13cmos5l_fill_2
X_2520_ _2525_/B _2544_/A _2520_/B _2520_/C _2555_/C VPWR VGND sg13cmos5l_nor4_1
X_2451_ _2553_/B _2206_/A _2205_/B _2506_/C VPWR VGND sg13cmos5l_a21oi_1
Xinput4 input4/X ui_in[2] VPWR VGND sg13cmos5l_buf_1
X_3003_ _3003_/Y _3003_/A _3003_/B VPWR VGND sg13cmos5l_xnor2_1
X_2382_ _2677_/B _2369_/C _2555_/B VPWR VGND sg13cmos5l_nand2b_1
XFILLER_24_316 VPWR VGND sg13cmos5l_fill_2
X_2718_ _2722_/B _2769_/A _2769_/B VPWR VGND sg13cmos5l_nand2_1
X_2649_ _3339_/D _1651_/Y _2671_/A2 _2591_/Y _2648_/Y VPWR VGND sg13cmos5l_a22oi_1
XFILLER_35_66 VPWR VGND sg13cmos5l_decap_8
XFILLER_35_77 VPWR VGND sg13cmos5l_fill_1
XFILLER_42_124 VPWR VGND sg13cmos5l_decap_8
XFILLER_18_176 VPWR VGND sg13cmos5l_fill_1
XFILLER_21_319 VPWR VGND sg13cmos5l_fill_2
XFILLER_33_102 VPWR VGND sg13cmos5l_decap_8
XFILLER_14_382 VPWR VGND sg13cmos5l_decap_4
X_1882_ _2024_/A _2076_/A _1886_/B VPWR VGND sg13cmos5l_nor2_1
X_1951_ _1951_/Y _2023_/A _1663_/Y _3343_/Q VPWR VGND sg13cmos5l_a21oi_1
XFILLER_37_0 VPWR VGND sg13cmos5l_decap_8
X_2503_ _2565_/A _2503_/A _2503_/B _2552_/A _2503_/D VPWR VGND sg13cmos5l_and4_1
X_2434_ _2523_/B _2450_/A _2136_/Y _2498_/B VPWR VGND sg13cmos5l_a21oi_1
X_2365_ _2489_/A _2435_/B _2158_/Y _2363_/Y VPWR VGND sg13cmos5l_o21ai_1
X_2296_ _2296_/Y _3066_/A _2296_/B VPWR VGND sg13cmos5l_nor2_1
XFILLER_24_179 VPWR VGND sg13cmos5l_decap_4
XFILLER_21_68 VPWR VGND sg13cmos5l_fill_1
XFILLER_47_205 VPWR VGND sg13cmos5l_fill_2
XFILLER_46_32 VPWR VGND sg13cmos5l_fill_1
XFILLER_30_127 VPWR VGND sg13cmos5l_fill_1
Xclkbuf_5_31__f_clk _3402_/CLK clkbuf_4_15_0_clk/X VPWR VGND sg13cmos5l_buf_8
XFILLER_38_205 VPWR VGND sg13cmos5l_decap_4
X_2081_ _2086_/A _2659_/A _2081_/B VPWR VGND sg13cmos5l_xnor2_1
X_2150_ _2436_/B _2098_/A _2150_/B VPWR VGND sg13cmos5l_nand2b_1
X_1934_ _1935_/B _1934_/A _3055_/A VPWR VGND sg13cmos5l_xnor2_1
X_2983_ _2985_/A _2941_/B _2935_/C _2980_/B VPWR VGND sg13cmos5l_o21ai_1
X_1796_ _1916_/A _2351_/C _2351_/D _2246_/B VPWR VGND sg13cmos5l_nand3b_1
X_1865_ _1865_/Y _3101_/B _1865_/B _1865_/C VPWR VGND sg13cmos5l_nand3_1
X_3397_ _3397_/Q _3413_/CLK _3397_/D fanout186/X VPWR VGND sg13cmos5l_dfrbpq_1
X_2417_ _2418_/D _2248_/A _2205_/B _2431_/C VPWR VGND sg13cmos5l_a21oi_1
X_2348_ _2349_/D _2425_/B _2404_/A _2348_/C VPWR VGND sg13cmos5l_nand3_1
X_2279_ _2404_/A _2180_/Y _2279_/B VPWR VGND sg13cmos5l_nand2b_1
XFILLER_20_171 VPWR VGND sg13cmos5l_decap_8
XFILLER_32_23 VPWR VGND sg13cmos5l_fill_2
XFILLER_32_34 VPWR VGND sg13cmos5l_decap_8
XFILLER_35_219 VPWR VGND sg13cmos5l_fill_1
XFILLER_7_186 VPWR VGND sg13cmos5l_fill_2
X_1650_ _2667_/A _2023_/A VPWR VGND sg13cmos5l_inv_1
X_2202_ _2543_/B _2462_/A VPWR VGND sg13cmos5l_inv_1
X_3320_ _3454_/A clkload0/A _3320_/D fanout164/X VPWR VGND sg13cmos5l_dfrbpq_1
X_3251_ _3251_/Y _3190_/A _2326_/B _3249_/Y _3250_/Y VPWR VGND sg13cmos5l_a22oi_1
X_3182_ _3183_/B _3181_/A _3370_/Q _3181_/B VPWR VGND sg13cmos5l_o21ai_1
XFILLER_19_271 VPWR VGND sg13cmos5l_decap_8
XFILLER_34_241 VPWR VGND sg13cmos5l_fill_1
X_2064_ _2064_/Y _2064_/A _2068_/A _2064_/C _2066_/B VPWR VGND sg13cmos5l_nor4_1
X_2133_ _2133_/X _2178_/A _2134_/B VPWR VGND sg13cmos5l_and2_1
XFILLER_22_403 VPWR VGND sg13cmos5l_fill_1
X_1917_ _1917_/Y _3274_/A _1918_/D VPWR VGND sg13cmos5l_nor2_1
X_2966_ _2966_/Y _2966_/A _2966_/B _2966_/C VPWR VGND sg13cmos5l_nand3_1
X_2897_ _2897_/Y _2109_/B _2899_/C _2895_/Y VPWR VGND sg13cmos5l_o21ai_1
X_1779_ _1823_/B _1862_/B _1862_/C VPWR VGND sg13cmos5l_nor2_1
X_1848_ _1849_/D _1848_/A _2049_/A VPWR VGND sg13cmos5l_nand2_1
X_3449_ _3449_/X _3453_/A VPWR VGND sg13cmos5l_buf_1
XFILLER_13_403 VPWR VGND sg13cmos5l_fill_1
XFILLER_27_89 VPWR VGND sg13cmos5l_fill_1
XFILLER_43_22 VPWR VGND sg13cmos5l_decap_8
XFILLER_43_66 VPWR VGND sg13cmos5l_decap_8
XFILLER_4_167 VPWR VGND sg13cmos5l_fill_1
XFILLER_31_211 VPWR VGND sg13cmos5l_decap_8
X_2820_ _3376_/D _2821_/B _2821_/C _2820_/C VPWR VGND sg13cmos5l_and3_1
X_2751_ _2751_/X _2751_/A _2751_/B VPWR VGND sg13cmos5l_and2_1
X_1702_ _3091_/A _3138_/A VPWR VGND sg13cmos5l_inv_1
X_2682_ _2710_/B _2693_/B _3360_/Q _2682_/C VPWR VGND sg13cmos5l_nand3_1
X_3303_ _3303_/Q _3389_/CLK _3303_/D fanout175/X VPWR VGND sg13cmos5l_dfrbpq_1
X_3234_ _3234_/Y _3124_/A _1969_/B _3232_/Y VPWR VGND sg13cmos5l_o21ai_1
X_3165_ _3165_/Y _3165_/A _3208_/A _3165_/C VPWR VGND sg13cmos5l_nand3_1
X_2047_ _2048_/B _2002_/A _2002_/B _1965_/B VPWR VGND sg13cmos5l_o21ai_1
X_2116_ _2117_/B _2248_/A _2265_/A VPWR VGND sg13cmos5l_nand2_1
Xfanout15 _3294_/A2 _2676_/A2 VPWR VGND sg13cmos5l_buf_1
Xfanout26 _2642_/A _2375_/Y VPWR VGND sg13cmos5l_buf_1
Xfanout37 _2832_/B _2779_/Y VPWR VGND sg13cmos5l_buf_1
X_3096_ _3263_/A _3217_/C _3095_/Y _3179_/A VPWR VGND sg13cmos5l_a21oi_1
Xfanout48 _2450_/B _2133_/X VPWR VGND sg13cmos5l_buf_1
Xfanout59 _2412_/A _1741_/X VPWR VGND sg13cmos5l_buf_1
X_2949_ _3297_/D _2949_/A VPWR VGND sg13cmos5l_inv_1
XFILLER_38_33 VPWR VGND sg13cmos5l_fill_2
XFILLER_38_44 VPWR VGND sg13cmos5l_decap_4
XFILLER_38_77 VPWR VGND sg13cmos5l_decap_8
XFILLER_38_88 VPWR VGND sg13cmos5l_fill_1
XFILLER_13_200 VPWR VGND sg13cmos5l_decap_4
XFILLER_13_244 VPWR VGND sg13cmos5l_fill_1
XFILLER_9_215 VPWR VGND sg13cmos5l_decap_8
X_2803_ _2804_/B _3144_/C _2803_/B VPWR VGND sg13cmos5l_xor2_1
X_2734_ _2734_/Y _2763_/A _2734_/B _2734_/C VPWR VGND sg13cmos5l_nand3b_1
X_2665_ _2666_/C _2665_/A1 _2653_/A _2667_/B VPWR VGND sg13cmos5l_o21ai_1
X_2596_ _2597_/C _2604_/A _2596_/B _2604_/B VPWR VGND sg13cmos5l_or3_1
X_3217_ _3263_/B _3217_/A _3217_/B _3217_/C _3217_/D VPWR VGND sg13cmos5l_nand4_1
X_3148_ _3166_/B _3091_/A _3145_/Y _3147_/Y VPWR VGND sg13cmos5l_a21oi_1
X_3079_ _3080_/C _3164_/D _3217_/B VPWR VGND sg13cmos5l_nand2b_1
XFILLER_6_218 VPWR VGND sg13cmos5l_fill_1
XFILLER_49_32 VPWR VGND sg13cmos5l_decap_8
Xhold270 _1681_/A _3352_/Q VPWR VGND sg13cmos5l_dlygate4sd3_1
Xhold281 _3404_/D _2906_/Y VPWR VGND sg13cmos5l_dlygate4sd3_1
Xhold292 _2889_/B _3399_/Q VPWR VGND sg13cmos5l_dlygate4sd3_1
XFILLER_18_314 VPWR VGND sg13cmos5l_fill_1
XFILLER_45_155 VPWR VGND sg13cmos5l_decap_8
XFILLER_45_166 VPWR VGND sg13cmos5l_fill_2
X_2450_ _2456_/C _2450_/A _2450_/B VPWR VGND sg13cmos5l_nand2_1
X_2381_ _2428_/C _2198_/B _2265_/B _2380_/A _2380_/B VPWR VGND sg13cmos5l_a22oi_1
XFILLER_36_133 VPWR VGND sg13cmos5l_decap_4
Xinput5 input5/X ui_in[3] VPWR VGND sg13cmos5l_buf_1
X_3002_ _3003_/B _3002_/A _3001_/X VPWR VGND sg13cmos5l_nor2b_1
XFILLER_36_199 VPWR VGND sg13cmos5l_decap_4
X_2717_ _2736_/B _2769_/A _2769_/B _2717_/C VPWR VGND sg13cmos5l_nor3_1
X_2648_ _2648_/Y _2645_/X _2664_/B _2647_/Y VPWR VGND sg13cmos5l_o21ai_1
X_2579_ _3285_/B _1848_/A _3288_/B _2578_/Y VPWR VGND sg13cmos5l_o21ai_1
XFILLER_27_177 VPWR VGND sg13cmos5l_decap_8
XFILLER_42_103 VPWR VGND sg13cmos5l_decap_8
XFILLER_30_309 VPWR VGND sg13cmos5l_fill_2
XFILLER_42_169 VPWR VGND sg13cmos5l_decap_8
XFILLER_18_144 VPWR VGND sg13cmos5l_fill_1
XFILLER_18_166 VPWR VGND sg13cmos5l_decap_4
XFILLER_33_169 VPWR VGND sg13cmos5l_fill_2
X_1950_ _1950_/Y _1943_/Y _1944_/Y _1942_/Y VPWR VGND sg13cmos5l_o21ai_1
X_1881_ _1886_/B _2984_/A _1903_/B VPWR VGND sg13cmos5l_nand2_1
X_2502_ _2503_/D _2502_/A _2508_/A _2528_/B _2502_/D VPWR VGND sg13cmos5l_and4_1
X_2433_ _2498_/B _2433_/A _2433_/B VPWR VGND sg13cmos5l_nor2_1
X_2364_ _2399_/B _2363_/A _2363_/B _2245_/B _2370_/A VPWR VGND sg13cmos5l_a22oi_1
X_2295_ _2295_/Y _3055_/A _2319_/B _2092_/D _3054_/A VPWR VGND sg13cmos5l_a22oi_1
XFILLER_20_331 VPWR VGND sg13cmos5l_fill_2
XFILLER_32_191 VPWR VGND sg13cmos5l_decap_8
XFILLER_21_47 VPWR VGND sg13cmos5l_fill_1
XFILLER_46_11 VPWR VGND sg13cmos5l_fill_1
XFILLER_46_66 VPWR VGND sg13cmos5l_decap_8
XFILLER_46_77 VPWR VGND sg13cmos5l_fill_1
XFILLER_46_99 VPWR VGND sg13cmos5l_decap_4
XFILLER_11_353 VPWR VGND sg13cmos5l_decap_8
XFILLER_23_180 VPWR VGND sg13cmos5l_fill_1
XFILLER_7_346 VPWR VGND sg13cmos5l_fill_2
Xclkbuf_4_9_0_clk clkbuf_4_9_0_clk/X clkbuf_0_clk/X VPWR VGND sg13cmos5l_buf_8
X_2080_ _2080_/Y _3254_/B VPWR VGND sg13cmos5l_inv_1
X_1933_ _1946_/C _1934_/A _1933_/B VPWR VGND sg13cmos5l_nor2_1
X_2982_ _3302_/D _2976_/A _2950_/B _2981_/Y VPWR VGND sg13cmos5l_a21o_1
X_1795_ _2246_/B _1795_/A _2096_/A VPWR VGND sg13cmos5l_or2_1
X_1864_ _1864_/Y _3296_/Q _2322_/A VPWR VGND sg13cmos5l_nand2_1
XFILLER_29_239 VPWR VGND sg13cmos5l_fill_1
X_2278_ _2279_/B _2278_/A _2278_/B VPWR VGND sg13cmos5l_nor2_1
X_3396_ _3396_/Q _3413_/CLK _3396_/D fanout186/X VPWR VGND sg13cmos5l_dfrbpq_1
X_2416_ _2506_/B _2351_/A _2436_/A _2415_/Y VPWR VGND sg13cmos5l_o21ai_1
X_2347_ _2348_/C _2551_/A _2347_/B _2514_/A VPWR VGND sg13cmos5l_nor3_1
XFILLER_28_250 VPWR VGND sg13cmos5l_decap_8
XFILLER_35_209 VPWR VGND sg13cmos5l_fill_1
XFILLER_7_165 VPWR VGND sg13cmos5l_fill_1
XFILLER_3_393 VPWR VGND sg13cmos5l_fill_2
X_2132_ _2132_/X _2158_/B _2142_/B VPWR VGND sg13cmos5l_and2_1
X_2201_ _2462_/A _2433_/B _2158_/Y _2274_/C VPWR VGND sg13cmos5l_a21oi_1
X_3250_ _3250_/Y _3375_/Q _2319_/B _2092_/D _3054_/B VPWR VGND sg13cmos5l_a22oi_1
X_3181_ _3181_/Y _3181_/A _3181_/B _3370_/Q VPWR VGND sg13cmos5l_nor3_1
X_2063_ _2063_/Y _2063_/A _2063_/B _2063_/C VPWR VGND sg13cmos5l_nor3_1
XFILLER_34_297 VPWR VGND sg13cmos5l_fill_1
X_1847_ _2060_/A _2586_/A _1847_/B VPWR VGND sg13cmos5l_and2_1
X_1916_ _1918_/D _1916_/A _1916_/B _1916_/C VPWR VGND sg13cmos5l_nor3_1
X_2965_ _2967_/A _2966_/A _2966_/C _2966_/B VPWR VGND sg13cmos5l_a21oi_1
X_2896_ _2896_/Y _3401_/Q _2899_/C VPWR VGND sg13cmos5l_nor2_1
X_1778_ _1862_/C _2007_/A _1865_/B _2028_/A VPWR VGND sg13cmos5l_a21oi_1
X_3448_ _3448_/X _3452_/A VPWR VGND sg13cmos5l_buf_1
XFILLER_17_209 VPWR VGND sg13cmos5l_decap_8
X_3379_ _3379_/Q _3379_/CLK _3379_/D fanout177/X VPWR VGND sg13cmos5l_dfrbpq_1
XFILLER_25_220 VPWR VGND sg13cmos5l_decap_4
XFILLER_25_253 VPWR VGND sg13cmos5l_decap_8
XFILLER_43_45 VPWR VGND sg13cmos5l_decap_8
XFILLER_43_89 VPWR VGND sg13cmos5l_decap_8
XFILLER_16_242 VPWR VGND sg13cmos5l_decap_8
XFILLER_16_253 VPWR VGND sg13cmos5l_fill_1
XFILLER_16_286 VPWR VGND sg13cmos5l_decap_8
XFILLER_31_234 VPWR VGND sg13cmos5l_decap_8
XFILLER_31_256 VPWR VGND sg13cmos5l_fill_1
X_1701_ _3269_/A _3089_/B VPWR VGND sg13cmos5l_inv_1
X_2750_ _3357_/D _2751_/A _2757_/A2 _2750_/S VPWR VGND sg13cmos5l_mux2_1
X_2681_ _2703_/B _2693_/B _3360_/Q _2751_/B VPWR VGND sg13cmos5l_or3_1
X_3302_ _3302_/Q _3376_/CLK _3302_/D fanout175/X VPWR VGND sg13cmos5l_dfrbpq_1
X_2115_ _2115_/X _2214_/B _2142_/B VPWR VGND sg13cmos5l_and2_1
X_3233_ _3233_/Y _3386_/Q _3233_/B VPWR VGND sg13cmos5l_nor2_1
X_3164_ _3175_/B _3265_/A _3265_/B _3164_/C _3164_/D VPWR VGND sg13cmos5l_and4_1
X_3095_ _3095_/Y _3140_/B _3095_/B VPWR VGND sg13cmos5l_nor2_1
XFILLER_22_223 VPWR VGND sg13cmos5l_fill_2
X_2046_ _2054_/B _3288_/A _2051_/B _2046_/C _2046_/D VPWR VGND sg13cmos5l_nand4_1
Xfanout16 _2671_/A2 _2676_/A2 VPWR VGND sg13cmos5l_buf_1
Xfanout27 _3286_/A _2656_/A VPWR VGND sg13cmos5l_buf_1
Xfanout38 _2337_/B _2296_/B VPWR VGND sg13cmos5l_buf_1
Xfanout49 _2412_/B _2132_/X VPWR VGND sg13cmos5l_buf_1
X_2948_ _2948_/Y _3101_/B _2942_/Y _2980_/A _2947_/Y VPWR VGND sg13cmos5l_a22oi_1
X_2879_ _2879_/Y _2882_/B _2878_/Y _2885_/D VPWR VGND sg13cmos5l_o21ai_1
XFILLER_49_109 VPWR VGND sg13cmos5l_decap_8
XFILLER_9_238 VPWR VGND sg13cmos5l_fill_2
XFILLER_48_120 VPWR VGND sg13cmos5l_fill_2
XFILLER_48_142 VPWR VGND sg13cmos5l_decap_8
X_2802_ _2803_/B _3269_/B _3269_/C _2860_/A VPWR VGND sg13cmos5l_nand3_1
X_2733_ _2733_/Y _3150_/A _2767_/B _2713_/Y _2732_/Y VPWR VGND sg13cmos5l_a22oi_1
X_2664_ _2666_/B _2664_/A _2664_/B _2664_/C VPWR VGND sg13cmos5l_nand3_1
XFILLER_5_93 VPWR VGND sg13cmos5l_fill_1
X_2595_ _2597_/B _2604_/A _2596_/B _2604_/B VPWR VGND sg13cmos5l_o21ai_1
XFILLER_39_186 VPWR VGND sg13cmos5l_decap_8
X_3216_ _3259_/C _3156_/A _2063_/B _3215_/Y VPWR VGND sg13cmos5l_o21ai_1
X_3147_ _3147_/Y _3136_/B _3272_/C _3129_/Y VPWR VGND sg13cmos5l_o21ai_1
X_3078_ _3217_/B _3156_/A _3078_/B VPWR VGND sg13cmos5l_nor2_1
XFILLER_24_47 VPWR VGND sg13cmos5l_fill_2
XFILLER_42_329 VPWR VGND sg13cmos5l_fill_1
X_2029_ _2029_/Y _2029_/A _2029_/B VPWR VGND sg13cmos5l_nand2_1
XFILLER_40_46 VPWR VGND sg13cmos5l_decap_4
XFILLER_40_68 VPWR VGND sg13cmos5l_fill_2
XFILLER_49_11 VPWR VGND sg13cmos5l_decap_8
Xhold260 _3349_/D _2711_/Y VPWR VGND sg13cmos5l_dlygate4sd3_1
Xhold271 _3352_/D _2733_/Y VPWR VGND sg13cmos5l_dlygate4sd3_1
XFILLER_49_88 VPWR VGND sg13cmos5l_decap_8
Xhold282 _2109_/B _3401_/Q VPWR VGND sg13cmos5l_dlygate4sd3_1
Xhold293 _3399_/D _2890_/Y VPWR VGND sg13cmos5l_dlygate4sd3_1
XFILLER_45_123 VPWR VGND sg13cmos5l_fill_2
Xclkbuf_5_14__f_clk _3388_/CLK clkbuf_4_7_0_clk/X VPWR VGND sg13cmos5l_buf_8
X_2380_ _2549_/A _2380_/A _2380_/B VPWR VGND sg13cmos5l_nand2_1
XFILLER_36_112 VPWR VGND sg13cmos5l_decap_8
XFILLER_36_167 VPWR VGND sg13cmos5l_decap_8
X_3001_ _3001_/X _3050_/B _3028_/B VPWR VGND sg13cmos5l_or2_1
X_2716_ _2717_/C _2722_/A VPWR VGND sg13cmos5l_inv_1
X_2647_ _2647_/Y _2645_/X _2664_/B _2642_/A VPWR VGND sg13cmos5l_a21oi_1
XFILLER_19_58 VPWR VGND sg13cmos5l_fill_1
X_2578_ _2578_/Y _3282_/A _3282_/B VPWR VGND sg13cmos5l_nand2_1
XFILLER_42_159 VPWR VGND sg13cmos5l_decap_4
XFILLER_18_156 VPWR VGND sg13cmos5l_fill_2
X_1880_ _1903_/B _2941_/B _1900_/B VPWR VGND sg13cmos5l_nor2_1
X_2501_ _2502_/D _2501_/A _2501_/B _2501_/C VPWR VGND sg13cmos5l_nor3_1
X_2294_ _2303_/B _3054_/A _2294_/B _2315_/C VPWR VGND sg13cmos5l_nand3_1
X_2432_ _2535_/C _2432_/A _2275_/D VPWR VGND sg13cmos5l_nor2b_1
X_2363_ _2363_/Y _2363_/A _2363_/B VPWR VGND sg13cmos5l_nand2_1
XFILLER_24_126 VPWR VGND sg13cmos5l_fill_2
XFILLER_46_23 VPWR VGND sg13cmos5l_decap_8
XFILLER_47_207 VPWR VGND sg13cmos5l_fill_1
XFILLER_11_332 VPWR VGND sg13cmos5l_decap_8
XFILLER_11_387 VPWR VGND sg13cmos5l_fill_2
XFILLER_7_358 VPWR VGND sg13cmos5l_fill_2
XFILLER_38_218 VPWR VGND sg13cmos5l_decap_8
XFILLER_38_229 VPWR VGND sg13cmos5l_fill_2
X_1863_ _1863_/Y _2952_/A _1866_/B VPWR VGND sg13cmos5l_nand2_1
X_1932_ _1932_/X _1945_/A _1945_/B _1935_/A VPWR VGND sg13cmos5l_or3_1
X_2981_ _2981_/Y _2979_/A _2979_/B _2980_/Y VPWR VGND sg13cmos5l_a21oi_1
XFILLER_42_0 VPWR VGND sg13cmos5l_decap_8
X_1794_ _2096_/A _1849_/B _2593_/A _1847_/B VPWR VGND sg13cmos5l_nand3_1
X_2415_ _2415_/Y _2415_/A _2415_/B VPWR VGND sg13cmos5l_nand2_1
X_2277_ _2347_/B _2277_/A _2476_/B _2277_/C _2277_/D VPWR VGND sg13cmos5l_nand4_1
X_3395_ _3395_/Q _3402_/CLK _3395_/D fanout183/X VPWR VGND sg13cmos5l_dfrbpq_1
X_2346_ _2349_/C _2485_/A _2562_/B VPWR VGND sg13cmos5l_nand2b_1
XFILLER_37_273 VPWR VGND sg13cmos5l_fill_2
XFILLER_28_262 VPWR VGND sg13cmos5l_fill_1
X_2062_ _2063_/C _2062_/A _2062_/B VPWR VGND sg13cmos5l_xnor2_1
X_2131_ _2226_/A _2939_/A _2494_/B VPWR VGND sg13cmos5l_nand2_1
X_2200_ _2224_/B _2476_/A _2200_/B VPWR VGND sg13cmos5l_nand2_1
X_3180_ _3180_/Y _3180_/A _3180_/B VPWR VGND sg13cmos5l_nand2_1
XFILLER_19_295 VPWR VGND sg13cmos5l_decap_8
X_2964_ _2966_/C _3116_/A _2935_/C _2960_/A VPWR VGND sg13cmos5l_a21o_1
X_1777_ _1777_/Y _2633_/A _1865_/B _1991_/B VPWR VGND sg13cmos5l_a21oi_1
X_1846_ _1853_/A _2076_/A _2302_/B _2992_/A VPWR VGND sg13cmos5l_or3_1
X_1915_ _2444_/B _2274_/C _2197_/B VPWR VGND sg13cmos5l_nor2_1
X_2895_ _2895_/Y _2109_/B _2932_/B _2899_/C VPWR VGND sg13cmos5l_o21ai_1
X_3447_ _3447_/X _3451_/A VPWR VGND sg13cmos5l_buf_1
X_3378_ _3378_/Q _3379_/CLK _3378_/D fanout177/X VPWR VGND sg13cmos5l_dfrbpq_1
X_2329_ _2329_/Y _2325_/Y _2327_/Y _2328_/Y VPWR VGND sg13cmos5l_o21ai_1
XFILLER_25_243 VPWR VGND sg13cmos5l_fill_2
XFILLER_25_276 VPWR VGND sg13cmos5l_decap_4
XFILLER_43_79 VPWR VGND sg13cmos5l_fill_1
Xclkbuf_4_8_0_clk clkbuf_4_8_0_clk/X clkbuf_0_clk/X VPWR VGND sg13cmos5l_buf_8
XFILLER_16_210 VPWR VGND sg13cmos5l_decap_8
XFILLER_16_265 VPWR VGND sg13cmos5l_decap_8
X_1700_ _3115_/B _3089_/A VPWR VGND sg13cmos5l_inv_1
X_2680_ _2751_/B _2680_/A _2750_/S VPWR VGND sg13cmos5l_xor2_1
X_3301_ _3301_/Q _3373_/CLK _3301_/D fanout176/X VPWR VGND sg13cmos5l_dfrbpq_1
X_3232_ _3232_/Y _3229_/Y _3230_/Y _3231_/Y VPWR VGND sg13cmos5l_o21ai_1
X_2045_ _2046_/D _2594_/A _3331_/Q _3332_/Q VPWR VGND sg13cmos5l_and3_1
X_2114_ _2142_/B _3423_/Q _3424_/Q VPWR VGND sg13cmos5l_nor2_1
X_3163_ _3163_/Y _3346_/Q _3167_/B _3167_/C VPWR VGND sg13cmos5l_nand3_1
X_3094_ _3095_/B _3156_/A _3265_/C _3123_/C VPWR VGND sg13cmos5l_nand3_1
XFILLER_22_235 VPWR VGND sg13cmos5l_decap_8
Xfanout17 _2676_/A2 _2570_/Y VPWR VGND sg13cmos5l_buf_1
Xfanout28 _2984_/B _2220_/X VPWR VGND sg13cmos5l_buf_1
Xfanout39 _3180_/B _1838_/B VPWR VGND sg13cmos5l_buf_1
X_2947_ _2947_/Y _2947_/A _2947_/B VPWR VGND sg13cmos5l_xnor2_1
X_1829_ _1831_/B _2302_/B _2993_/C VPWR VGND sg13cmos5l_and2_1
X_2878_ _2878_/Y _2878_/A _2932_/B VPWR VGND sg13cmos5l_nor2_1
XFILLER_38_35 VPWR VGND sg13cmos5l_fill_1
XFILLER_45_305 VPWR VGND sg13cmos5l_fill_2
X_2801_ _2807_/B _3269_/C _2860_/A _2810_/B VPWR VGND sg13cmos5l_nand3_1
X_2732_ _2732_/Y _2770_/A _2732_/B _2732_/C VPWR VGND sg13cmos5l_nand3_1
X_2663_ _2664_/C _2663_/A _2659_/Y VPWR VGND sg13cmos5l_nor2b_1
X_2594_ _2604_/B _2594_/A _2606_/B VPWR VGND sg13cmos5l_xnor2_1
XFILLER_39_132 VPWR VGND sg13cmos5l_decap_4
X_3215_ _3215_/Y _3215_/A _3215_/B VPWR VGND sg13cmos5l_nand2_1
XFILLER_39_165 VPWR VGND sg13cmos5l_fill_1
X_2028_ _2029_/B _2028_/A _3116_/A _2028_/C VPWR VGND sg13cmos5l_nand3_1
X_3146_ _3272_/C _3146_/A _3146_/B VPWR VGND sg13cmos5l_and2_1
X_3077_ _3078_/B _3123_/C VPWR VGND sg13cmos5l_inv_1
XFILLER_40_25 VPWR VGND sg13cmos5l_fill_2
Xhold250 _1687_/A _3346_/Q VPWR VGND sg13cmos5l_dlygate4sd3_1
Xhold261 _1682_/A _3353_/Q VPWR VGND sg13cmos5l_dlygate4sd3_1
Xhold272 hold272/X _3420_/Q VPWR VGND sg13cmos5l_dlygate4sd3_1
Xhold283 _3401_/D _2897_/Y VPWR VGND sg13cmos5l_dlygate4sd3_1
Xhold294 hold294/X _3356_/Q VPWR VGND sg13cmos5l_dlygate4sd3_1
XFILLER_18_338 VPWR VGND sg13cmos5l_decap_4
XFILLER_18_349 VPWR VGND sg13cmos5l_fill_2
XFILLER_45_102 VPWR VGND sg13cmos5l_fill_1
XFILLER_45_113 VPWR VGND sg13cmos5l_decap_4
XFILLER_49_67 VPWR VGND sg13cmos5l_decap_8
X_3000_ _3002_/A _3050_/B _3028_/B VPWR VGND sg13cmos5l_and2_1
X_2715_ _2722_/A _2763_/A _2734_/B VPWR VGND sg13cmos5l_xnor2_1
X_2646_ _2664_/B _2646_/A _2646_/B VPWR VGND sg13cmos5l_xnor2_1
X_2577_ _3282_/B _2577_/A _3288_/B VPWR VGND sg13cmos5l_xnor2_1
XFILLER_23_330 VPWR VGND sg13cmos5l_fill_2
XFILLER_27_146 VPWR VGND sg13cmos5l_decap_8
XFILLER_35_47 VPWR VGND sg13cmos5l_decap_8
XFILLER_42_138 VPWR VGND sg13cmos5l_decap_8
Xclkbuf_5_20__f_clk _3422_/CLK clkbuf_4_10_0_clk/X VPWR VGND sg13cmos5l_buf_8
X_3129_ _3129_/Y _3138_/A _3137_/A _3138_/C VPWR VGND sg13cmos5l_a21oi_1
XFILLER_33_116 VPWR VGND sg13cmos5l_decap_8
X_2500_ _2501_/C _2543_/B _2500_/B _2500_/C _2500_/D VPWR VGND sg13cmos5l_nand4_1
X_2431_ _2456_/B _2485_/A _2431_/B _2431_/C _2431_/D VPWR VGND sg13cmos5l_nor4_1
X_2293_ _2293_/X _2293_/A _2293_/B _2293_/C VPWR VGND sg13cmos5l_or3_1
X_2362_ _2535_/A _2216_/A _2415_/A _2265_/B VPWR VGND sg13cmos5l_o21ai_1
XFILLER_20_333 VPWR VGND sg13cmos5l_fill_1
XFILLER_32_171 VPWR VGND sg13cmos5l_fill_2
X_2629_ _2629_/Y _2626_/X _2628_/X _3286_/A VPWR VGND sg13cmos5l_o21ai_1
XFILLER_46_46 VPWR VGND sg13cmos5l_decap_8
XFILLER_34_403 VPWR VGND sg13cmos5l_fill_1
XFILLER_36_90 VPWR VGND sg13cmos5l_fill_2
X_2980_ _2980_/Y _2980_/A _2980_/B VPWR VGND sg13cmos5l_nand2_1
XFILLER_21_119 VPWR VGND sg13cmos5l_fill_1
X_1793_ _1847_/B _2594_/A _3333_/Q _2063_/A VPWR VGND sg13cmos5l_nor3_1
X_1862_ _1888_/A _3098_/A _1862_/B _1862_/C VPWR VGND sg13cmos5l_or3_1
X_1931_ _1935_/A _3338_/Q _3014_/A VPWR VGND sg13cmos5l_xnor2_1
XFILLER_35_0 VPWR VGND sg13cmos5l_decap_8
X_3394_ _3394_/Q _3394_/CLK _3394_/D fanout183/X VPWR VGND sg13cmos5l_dfrbpq_1
X_2414_ _2431_/C _2274_/C _2435_/A _2464_/B VPWR VGND sg13cmos5l_o21ai_1
XFILLER_25_403 VPWR VGND sg13cmos5l_fill_1
XFILLER_37_241 VPWR VGND sg13cmos5l_fill_2
X_2276_ _2277_/D _2276_/A _2506_/A _2276_/C _2276_/D VPWR VGND sg13cmos5l_nor4_1
X_2345_ _2457_/A _2497_/B _2357_/B VPWR VGND sg13cmos5l_nor2b_1
XFILLER_16_27 VPWR VGND sg13cmos5l_fill_1
XFILLER_37_296 VPWR VGND sg13cmos5l_fill_2
XFILLER_32_48 VPWR VGND sg13cmos5l_decap_8
XFILLER_28_274 VPWR VGND sg13cmos5l_fill_1
XFILLER_28_285 VPWR VGND sg13cmos5l_decap_8
XFILLER_28_296 VPWR VGND sg13cmos5l_decap_8
XFILLER_11_196 VPWR VGND sg13cmos5l_fill_2
XFILLER_3_384 VPWR VGND sg13cmos5l_fill_1
XFILLER_34_200 VPWR VGND sg13cmos5l_decap_4
X_2061_ _2061_/Y _1980_/A _2060_/Y _2059_/Y VPWR VGND sg13cmos5l_o21ai_1
X_2130_ _2494_/B _2516_/A _2510_/A VPWR VGND sg13cmos5l_nor2_1
XFILLER_34_211 VPWR VGND sg13cmos5l_decap_4
XFILLER_34_255 VPWR VGND sg13cmos5l_decap_4
X_1914_ _2197_/B _2147_/B _2178_/B VPWR VGND sg13cmos5l_nand2b_1
X_2963_ _2966_/B _2963_/A _2963_/B VPWR VGND sg13cmos5l_xnor2_1
X_1776_ _1991_/B _2646_/A _1937_/A _2028_/A VPWR VGND sg13cmos5l_nand3_1
X_1845_ _1860_/A _1845_/A _1843_/Y VPWR VGND sg13cmos5l_nor2b_1
X_2894_ _2894_/Y _2925_/B _2899_/C _2894_/C VPWR VGND sg13cmos5l_nand3_1
X_2328_ _2328_/Y _1899_/Y _2086_/A _2337_/B _1896_/X VPWR VGND sg13cmos5l_a22oi_1
X_3377_ _3377_/Q clkload2/A _3377_/D fanout177/X VPWR VGND sg13cmos5l_dfrbpq_1
XFILLER_43_14 VPWR VGND sg13cmos5l_fill_2
X_2259_ _2476_/B _2369_/C _2555_/B VPWR VGND sg13cmos5l_nand2_1
X_3300_ _3300_/Q _3373_/CLK _3300_/D fanout176/X VPWR VGND sg13cmos5l_dfrbpq_1
X_3231_ _3231_/Y _3208_/A _1969_/B _3229_/B _3229_/A VPWR VGND sg13cmos5l_a22oi_1
X_3162_ _3162_/Y _3345_/Q _3166_/B VPWR VGND sg13cmos5l_nand2_1
XFILLER_39_369 VPWR VGND sg13cmos5l_fill_1
X_2044_ _2485_/A _2436_/A _2433_/A _2402_/B VPWR VGND sg13cmos5l_nor3_1
X_2113_ _2248_/B _3420_/Q _2874_/C _3367_/Q VPWR VGND sg13cmos5l_a21oi_1
X_3093_ _3140_/B _3121_/A _3199_/A _3168_/C VPWR VGND sg13cmos5l_a21oi_1
XFILLER_22_225 VPWR VGND sg13cmos5l_fill_1
XFILLER_22_269 VPWR VGND sg13cmos5l_fill_2
Xfanout18 _2751_/A _2748_/A VPWR VGND sg13cmos5l_buf_1
Xfanout29 _2963_/B _2220_/X VPWR VGND sg13cmos5l_buf_1
Xclkbuf_5_1__f_clk clkload0/A clkbuf_4_0_0_clk/X VPWR VGND sg13cmos5l_buf_8
X_2946_ _2947_/B _3101_/B _2984_/B VPWR VGND sg13cmos5l_xnor2_1
X_2877_ _2885_/D _2878_/A _2882_/B VPWR VGND sg13cmos5l_nand2b_1
X_1759_ _2079_/A _2315_/B _2092_/A VPWR VGND sg13cmos5l_nor2b_1
X_1828_ _2993_/C _3066_/A _3055_/A _3014_/A VPWR VGND sg13cmos5l_or3_1
XFILLER_38_14 VPWR VGND sg13cmos5l_fill_1
X_3429_ _3429_/Q clkload4/A _3429_/D fanout172/X VPWR VGND sg13cmos5l_dfrbpq_1
XFILLER_13_214 VPWR VGND sg13cmos5l_fill_1
XFILLER_21_280 VPWR VGND sg13cmos5l_fill_2
XFILLER_9_229 VPWR VGND sg13cmos5l_fill_2
XFILLER_0_140 VPWR VGND sg13cmos5l_fill_1
XFILLER_48_122 VPWR VGND sg13cmos5l_fill_1
XFILLER_48_133 VPWR VGND sg13cmos5l_fill_1
XFILLER_12_280 VPWR VGND sg13cmos5l_fill_1
X_2800_ _2810_/B _3269_/B _3144_/C VPWR VGND sg13cmos5l_and2_1
X_2731_ _2732_/C _2728_/A _2730_/Y _2734_/B VPWR VGND sg13cmos5l_o21ai_1
XFILLER_8_273 VPWR VGND sg13cmos5l_fill_2
X_2662_ _3341_/D _2659_/A _2671_/A2 _2591_/Y _2661_/Y VPWR VGND sg13cmos5l_a22oi_1
X_2593_ _2596_/B _2593_/A _2606_/B VPWR VGND sg13cmos5l_nor2_1
XFILLER_39_144 VPWR VGND sg13cmos5l_decap_8
Xclkbuf_4_7_0_clk clkbuf_4_7_0_clk/X clkbuf_0_clk/X VPWR VGND sg13cmos5l_buf_8
X_3214_ _3215_/B _3387_/Q _2052_/A _3213_/Y VPWR VGND sg13cmos5l_o21ai_1
X_3145_ _3145_/Y _3145_/A _3145_/B _3145_/C VPWR VGND sg13cmos5l_nand3_1
X_2027_ _2027_/Y _2027_/A _2027_/B _2027_/C VPWR VGND sg13cmos5l_nor3_1
X_3076_ _3123_/C _3265_/B _3164_/C VPWR VGND sg13cmos5l_nor2_1
X_2929_ _2929_/Y _2929_/A _2932_/C VPWR VGND sg13cmos5l_nand2_1
XFILLER_49_46 VPWR VGND sg13cmos5l_decap_8
Xhold240 _3315_/D _1738_/X VPWR VGND sg13cmos5l_dlygate4sd3_1
Xhold251 _3346_/D _2700_/Y VPWR VGND sg13cmos5l_dlygate4sd3_1
Xhold262 _2923_/B _3410_/Q VPWR VGND sg13cmos5l_dlygate4sd3_1
Xhold273 _3420_/D _1734_/X VPWR VGND sg13cmos5l_dlygate4sd3_1
Xhold284 _1688_/A _3347_/Q VPWR VGND sg13cmos5l_dlygate4sd3_1
Xhold295 _3356_/D _2749_/X VPWR VGND sg13cmos5l_dlygate4sd3_1
XFILLER_18_306 VPWR VGND sg13cmos5l_fill_2
X_2714_ _2769_/C _2763_/A _2734_/B VPWR VGND sg13cmos5l_and2_1
X_2645_ _2645_/X hold354/X _2673_/B _2664_/A VPWR VGND sg13cmos5l_a21o_1
X_2576_ _3282_/A _3279_/B _3295_/Q VPWR VGND sg13cmos5l_nand2b_1
XFILLER_27_158 VPWR VGND sg13cmos5l_fill_1
X_3128_ _3317_/D _2832_/B _3259_/A _3044_/Y VPWR VGND sg13cmos5l_o21ai_1
XFILLER_42_117 VPWR VGND sg13cmos5l_decap_8
X_3059_ _3059_/Y _3254_/A _3059_/B VPWR VGND sg13cmos5l_nand2_1
XFILLER_14_342 VPWR VGND sg13cmos5l_decap_8
XFILLER_14_375 VPWR VGND sg13cmos5l_decap_8
XFILLER_41_161 VPWR VGND sg13cmos5l_decap_8
XFILLER_41_183 VPWR VGND sg13cmos5l_fill_2
X_2430_ _2431_/D _2430_/A _2476_/B _2430_/C _2430_/D VPWR VGND sg13cmos5l_nand4_1
X_2361_ _2455_/C _2361_/A _2361_/B VPWR VGND sg13cmos5l_or2_1
X_2292_ _2293_/C _3008_/A _2320_/B _2289_/Y _2290_/Y _2291_/Y VPWR VGND sg13cmos5l_a221oi_1
XFILLER_20_323 VPWR VGND sg13cmos5l_decap_4
XFILLER_32_150 VPWR VGND sg13cmos5l_decap_8
Xheichips26_heiscore uio_oe[0] VPWR VGND sg13cmos5l_tielo
X_2628_ _2628_/X _2628_/A _2667_/B VPWR VGND sg13cmos5l_xor2_1
X_2559_ _2560_/D _2559_/A _2559_/B _2559_/C _2559_/D VPWR VGND sg13cmos5l_nor4_1
XFILLER_11_301 VPWR VGND sg13cmos5l_decap_8
XFILLER_11_389 VPWR VGND sg13cmos5l_fill_1
XFILLER_11_50 VPWR VGND sg13cmos5l_fill_2
XFILLER_14_172 VPWR VGND sg13cmos5l_decap_8
X_1930_ _1945_/B _2633_/A _2990_/B _1927_/Y _1928_/Y _1929_/Y VPWR VGND sg13cmos5l_a221oi_1
X_1792_ _2593_/A _2586_/A _2573_/A VPWR VGND sg13cmos5l_nor2_1
X_1861_ _1861_/Y _2972_/A _3180_/B VPWR VGND sg13cmos5l_nand2_1
X_3393_ _3393_/Q _3394_/CLK _3393_/D fanout179/X VPWR VGND sg13cmos5l_dfrbpq_1
X_2413_ _2555_/C _2413_/A _2435_/A VPWR VGND sg13cmos5l_nor2_1
X_2344_ _2357_/B _2397_/A _2396_/B VPWR VGND sg13cmos5l_and2_1
X_2275_ _2276_/D _2493_/B _2275_/B _2540_/C _2275_/D VPWR VGND sg13cmos5l_nand4_1
XFILLER_28_231 VPWR VGND sg13cmos5l_decap_8
XFILLER_7_179 VPWR VGND sg13cmos5l_fill_2
X_2060_ _2060_/Y _2060_/A _2060_/B _2060_/C _2060_/D VPWR VGND sg13cmos5l_nand4_1
XFILLER_8_40 VPWR VGND sg13cmos5l_fill_2
X_1913_ _2198_/B _2147_/B _2157_/A VPWR VGND sg13cmos5l_nor2_1
X_2962_ _3299_/D _2962_/A VPWR VGND sg13cmos5l_inv_1
X_2893_ _2893_/Y _2893_/A _2893_/B VPWR VGND sg13cmos5l_nand2_1
X_1775_ _2289_/C _1816_/A _2628_/A _3181_/A VPWR VGND sg13cmos5l_or3_1
X_1844_ _1845_/A _3046_/A _1855_/A _1905_/B VPWR VGND sg13cmos5l_o21ai_1
X_2258_ _2555_/B _2413_/A _2379_/B VPWR VGND sg13cmos5l_nor2_1
X_2327_ _2327_/Y _1896_/X _2337_/B _2326_/Y VPWR VGND sg13cmos5l_o21ai_1
X_3376_ _3376_/Q _3376_/CLK _3376_/D fanout175/X VPWR VGND sg13cmos5l_dfrbpq_1
XFILLER_25_267 VPWR VGND sg13cmos5l_decap_4
X_2189_ _2226_/B _2558_/B _2494_/C VPWR VGND sg13cmos5l_nand2_1
XFILLER_43_59 VPWR VGND sg13cmos5l_decap_8
XFILLER_16_201 VPWR VGND sg13cmos5l_decap_4
XFILLER_3_193 VPWR VGND sg13cmos5l_fill_1
X_2112_ _2874_/C _2928_/A _2929_/A _2928_/C VPWR VGND sg13cmos5l_or3_1
X_3230_ _3230_/Y _3204_/A _1974_/A _3228_/Y VPWR VGND sg13cmos5l_o21ai_1
X_3161_ _3257_/A _3179_/B _3179_/C VPWR VGND sg13cmos5l_nor2_1
X_2043_ _2402_/B _2042_/Y _2043_/B VPWR VGND sg13cmos5l_nand2b_1
Xfanout19 _2748_/A _2569_/Y VPWR VGND sg13cmos5l_buf_1
X_3092_ _3179_/A _3156_/A _3078_/B _3087_/Y _3091_/Y VPWR VGND sg13cmos5l_a22oi_1
X_1827_ _1827_/Y _3180_/B VPWR VGND sg13cmos5l_inv_1
X_2945_ _2945_/Y _3101_/B _2984_/B VPWR VGND sg13cmos5l_nand2_1
X_2876_ _2876_/Y _1693_/Y _2873_/Y _2875_/Y VPWR VGND sg13cmos5l_o21ai_1
X_1689_ _1689_/Y _1689_/A VPWR VGND sg13cmos5l_inv_1
X_1758_ _2081_/B _2286_/A _2639_/A _2289_/B _1758_/D VPWR VGND sg13cmos5l_nand4_1
X_3428_ _3428_/Q clkload1/A _3428_/D fanout167/X VPWR VGND sg13cmos5l_dfrbpq_1
XFILLER_38_48 VPWR VGND sg13cmos5l_fill_2
X_3359_ _3359_/Q _3360_/CLK _3359_/D fanout166/X VPWR VGND sg13cmos5l_dfrbpq_1
XFILLER_13_204 VPWR VGND sg13cmos5l_fill_2
XFILLER_9_208 VPWR VGND sg13cmos5l_decap_8
XFILLER_28_92 VPWR VGND sg13cmos5l_fill_2
X_2730_ _2730_/Y _3363_/Q _2738_/B _3365_/Q VPWR VGND sg13cmos5l_nor3_1
X_2661_ _2661_/Y _2658_/Y _2659_/Y _2660_/Y VPWR VGND sg13cmos5l_o21ai_1
XFILLER_5_74 VPWR VGND sg13cmos5l_fill_1
X_2592_ _2604_/A _2592_/A _2586_/Y VPWR VGND sg13cmos5l_nor2b_1
X_3213_ _3213_/Y _3210_/Y _3211_/Y _3212_/Y VPWR VGND sg13cmos5l_a21oi_1
X_3144_ _3145_/C _3144_/A _3269_/B _3144_/C VPWR VGND sg13cmos5l_or3_1
X_3075_ _3174_/B _3168_/A _3217_/A VPWR VGND sg13cmos5l_nor2_1
X_2026_ _2026_/Y _2085_/A _2972_/A VPWR VGND sg13cmos5l_nand2_1
X_2928_ _2932_/C _2928_/A _3367_/Q _2928_/C VPWR VGND sg13cmos5l_nor3_1
X_2859_ _2860_/B _3265_/A _2859_/B VPWR VGND sg13cmos5l_xnor2_1
XFILLER_49_25 VPWR VGND sg13cmos5l_decap_8
Xhold230 _3392_/D _2872_/Y VPWR VGND sg13cmos5l_dlygate4sd3_1
Xhold241 _1684_/A _3355_/Q VPWR VGND sg13cmos5l_dlygate4sd3_1
Xhold252 _1724_/B _3418_/Q VPWR VGND sg13cmos5l_dlygate4sd3_1
Xhold263 _3410_/D _2924_/Y VPWR VGND sg13cmos5l_dlygate4sd3_1
Xhold274 _1680_/A _3351_/Q VPWR VGND sg13cmos5l_dlygate4sd3_1
Xhold285 _3347_/D _2704_/Y VPWR VGND sg13cmos5l_dlygate4sd3_1
Xhold296 hold296/X _3342_/Q VPWR VGND sg13cmos5l_dlygate4sd3_1
XFILLER_45_137 VPWR VGND sg13cmos5l_fill_1
XFILLER_45_148 VPWR VGND sg13cmos5l_decap_8
XFILLER_5_222 VPWR VGND sg13cmos5l_fill_2
XFILLER_36_126 VPWR VGND sg13cmos5l_decap_8
XFILLER_17_362 VPWR VGND sg13cmos5l_decap_4
XFILLER_36_137 VPWR VGND sg13cmos5l_fill_1
XFILLER_44_170 VPWR VGND sg13cmos5l_decap_4
X_2713_ _2713_/Y _1731_/Y _2740_/A _2677_/Y VPWR VGND sg13cmos5l_a21oi_1
X_2644_ _3338_/D _2639_/A _2676_/A2 _2591_/Y _2643_/Y VPWR VGND sg13cmos5l_a22oi_1
X_2575_ _3285_/A _2575_/A _3288_/B VPWR VGND sg13cmos5l_xnor2_1
X_3127_ _3259_/A _3127_/A _3263_/A _3127_/C VPWR VGND sg13cmos5l_and3_1
X_3058_ _3058_/Y _3190_/A _3058_/B VPWR VGND sg13cmos5l_nand2_1
XFILLER_35_170 VPWR VGND sg13cmos5l_decap_8
XFILLER_35_181 VPWR VGND sg13cmos5l_fill_1
X_2009_ _2009_/Y _1816_/A _3296_/Q VPWR VGND sg13cmos5l_nand2b_1
XFILLER_41_151 VPWR VGND sg13cmos5l_fill_1
Xclkbuf_4_6_0_clk clkbuf_4_6_0_clk/X clkbuf_0_clk/X VPWR VGND sg13cmos5l_buf_8
X_2291_ _2291_/Y _1753_/Y _2289_/C _3048_/A VPWR VGND sg13cmos5l_a21oi_1
X_2360_ _2421_/B _2516_/A _2455_/B VPWR VGND sg13cmos5l_or2_1
XFILLER_1_280 VPWR VGND sg13cmos5l_fill_1
XFILLER_20_302 VPWR VGND sg13cmos5l_decap_8
XFILLER_32_184 VPWR VGND sg13cmos5l_decap_8
XFILLER_20_368 VPWR VGND sg13cmos5l_fill_1
X_2627_ _2627_/X _2628_/A _2667_/B VPWR VGND sg13cmos5l_and2_1
XFILLER_28_402 VPWR VGND sg13cmos5l_fill_2
X_2558_ _2559_/D _2558_/A _2558_/B _2558_/C _2558_/D VPWR VGND sg13cmos5l_nand4_1
X_2489_ _2508_/A _2489_/A _2489_/B VPWR VGND sg13cmos5l_nor2_1
XFILLER_19_402 VPWR VGND sg13cmos5l_fill_2
XFILLER_36_92 VPWR VGND sg13cmos5l_fill_1
X_1860_ _1916_/B _1860_/A _1860_/B _1860_/C VPWR VGND sg13cmos5l_nor3_1
XFILLER_6_361 VPWR VGND sg13cmos5l_fill_1
X_1791_ _1849_/B _2037_/A _1975_/A _1999_/B VPWR VGND sg13cmos5l_o21ai_1
X_2274_ _2275_/D input2/X input3/X _2274_/C _2436_/A VPWR VGND sg13cmos5l_or4_1
X_3392_ _3392_/Q _3394_/CLK _3392_/D fanout179/X VPWR VGND sg13cmos5l_dfrbpq_1
X_2412_ _2464_/B _2412_/A _2412_/B VPWR VGND sg13cmos5l_nand2_1
X_2343_ _2397_/C _2333_/X _2342_/Y _2396_/B VPWR VGND sg13cmos5l_a21oi_1
XFILLER_37_298 VPWR VGND sg13cmos5l_fill_1
XFILLER_20_143 VPWR VGND sg13cmos5l_fill_1
X_1989_ _2278_/A _3229_/B _1989_/B _1989_/C _1989_/D VPWR VGND sg13cmos5l_nand4_1
XFILLER_28_243 VPWR VGND sg13cmos5l_decap_8
XFILLER_11_198 VPWR VGND sg13cmos5l_fill_1
X_1843_ _1843_/Y _1839_/Y _1841_/Y _1842_/Y VPWR VGND sg13cmos5l_o21ai_1
X_1912_ _2157_/A _3423_/Q _3424_/Q VPWR VGND sg13cmos5l_nand2b_1
X_2961_ _2962_/A _3098_/A _2950_/B _2980_/A _2960_/Y VPWR VGND sg13cmos5l_a22oi_1
X_2892_ _2902_/C _2892_/A _2892_/B VPWR VGND sg13cmos5l_nor2_1
XFILLER_40_0 VPWR VGND sg13cmos5l_decap_4
X_1774_ _1795_/A _2077_/A _1774_/B _1852_/A VPWR VGND sg13cmos5l_nand3_1
XFILLER_27_28 VPWR VGND sg13cmos5l_fill_1
X_2257_ _2277_/A _2257_/A _2554_/A _2536_/B _2388_/A VPWR VGND sg13cmos5l_nor4_1
X_2326_ _2326_/Y _2326_/A _2326_/B VPWR VGND sg13cmos5l_nand2_1
X_3375_ _3375_/Q _3376_/CLK _3375_/D fanout175/X VPWR VGND sg13cmos5l_dfrbpq_1
XFILLER_25_224 VPWR VGND sg13cmos5l_fill_1
X_2188_ _2494_/C _2376_/A _2477_/A _2188_/C VPWR VGND sg13cmos5l_nor3_1
XFILLER_16_224 VPWR VGND sg13cmos5l_decap_8
Xclkbuf_5_26__f_clk _3307_/CLK clkbuf_4_13_0_clk/X VPWR VGND sg13cmos5l_buf_8
XFILLER_16_279 VPWR VGND sg13cmos5l_decap_4
XFILLER_31_227 VPWR VGND sg13cmos5l_decap_8
XFILLER_31_249 VPWR VGND sg13cmos5l_decap_8
XFILLER_33_60 VPWR VGND sg13cmos5l_decap_8
XFILLER_33_71 VPWR VGND sg13cmos5l_fill_2
X_2042_ _2042_/Y _2042_/A _2042_/B _2042_/C VPWR VGND sg13cmos5l_nor3_1
X_2111_ _2928_/C _2892_/A _2111_/B VPWR VGND sg13cmos5l_or2_1
X_3160_ _3179_/C _3160_/A _3160_/B _3160_/C VPWR VGND sg13cmos5l_nor3_1
X_3091_ _3091_/Y _3091_/A _3091_/B _3171_/C _3146_/B VPWR VGND sg13cmos5l_nand4_1
XFILLER_22_216 VPWR VGND sg13cmos5l_decap_8
XFILLER_22_249 VPWR VGND sg13cmos5l_fill_2
X_1826_ _1838_/B _2085_/A _1826_/B VPWR VGND sg13cmos5l_xnor2_1
X_2944_ _3296_/D _2950_/B _2980_/A _3100_/A VPWR VGND sg13cmos5l_mux2_1
X_2875_ _2875_/Y _2932_/B _2882_/B VPWR VGND sg13cmos5l_nor2_1
X_1688_ _1688_/Y _1688_/A VPWR VGND sg13cmos5l_inv_1
X_1757_ _2085_/B _2646_/A _2286_/A _2639_/A _2289_/B VPWR VGND sg13cmos5l_nand4_1
X_3427_ _3427_/Q _3427_/CLK _3427_/D fanout173/X VPWR VGND sg13cmos5l_dfrbpq_1
X_3358_ _3358_/Q clkload0/A _3358_/D fanout164/X VPWR VGND sg13cmos5l_dfrbpq_1
X_2309_ _2309_/Y _1836_/B _2086_/A _2296_/B _1831_/B VPWR VGND sg13cmos5l_a22oi_1
X_3289_ _3290_/B _3289_/A _3289_/B VPWR VGND sg13cmos5l_xnor2_1
XFILLER_13_227 VPWR VGND sg13cmos5l_decap_4
XFILLER_21_282 VPWR VGND sg13cmos5l_fill_1
XFILLER_48_113 VPWR VGND sg13cmos5l_decap_8
XFILLER_8_242 VPWR VGND sg13cmos5l_decap_8
XFILLER_8_275 VPWR VGND sg13cmos5l_fill_1
X_2660_ _2660_/Y _2658_/Y _2659_/Y _2642_/A VPWR VGND sg13cmos5l_a21oi_1
X_3212_ _3212_/Y _3388_/Q _3212_/B VPWR VGND sg13cmos5l_nor2_1
X_2591_ _2591_/Y _2770_/A _2748_/A _2591_/C VPWR VGND sg13cmos5l_nor3_1
XFILLER_39_102 VPWR VGND sg13cmos5l_decap_8
XFILLER_39_113 VPWR VGND sg13cmos5l_fill_1
XFILLER_39_179 VPWR VGND sg13cmos5l_decap_8
X_2025_ _2072_/A _2021_/X _2022_/Y _2024_/X VPWR VGND sg13cmos5l_a21oi_1
X_3143_ _3143_/Y _3133_/Y _3139_/Y _3142_/Y _3217_/B _3140_/Y VPWR VGND sg13cmos5l_a221oi_1
X_3074_ _3217_/A _3121_/A _3199_/A _3168_/C VPWR VGND sg13cmos5l_o21ai_1
X_2927_ _2927_/Y _2927_/A _2927_/B VPWR VGND sg13cmos5l_nand2_1
XFILLER_40_39 VPWR VGND sg13cmos5l_decap_8
X_1809_ _1809_/Y _1862_/B _1862_/C _3054_/A VPWR VGND sg13cmos5l_o21ai_1
Xhold220 _3361_/D _2760_/Y VPWR VGND sg13cmos5l_dlygate4sd3_1
Xhold231 _1678_/A _3350_/Q VPWR VGND sg13cmos5l_dlygate4sd3_1
Xhold242 _3355_/D _2745_/Y VPWR VGND sg13cmos5l_dlygate4sd3_1
Xhold253 _3418_/D _1724_/X VPWR VGND sg13cmos5l_dlygate4sd3_1
X_2858_ _3388_/D _2858_/A _2859_/B VPWR VGND sg13cmos5l_nor2b_1
X_2789_ _2790_/D _3272_/A _3091_/B _3269_/D _2798_/B VPWR VGND sg13cmos5l_nand4_1
Xhold264 hold264/X _3454_/A VPWR VGND sg13cmos5l_dlygate4sd3_1
Xhold275 _3351_/D _2729_/Y VPWR VGND sg13cmos5l_dlygate4sd3_1
Xhold286 _2885_/B _3396_/Q VPWR VGND sg13cmos5l_dlygate4sd3_1
Xhold297 _3342_/D _2671_/X VPWR VGND sg13cmos5l_dlygate4sd3_1
XFILLER_14_51 VPWR VGND sg13cmos5l_fill_1
XFILLER_14_62 VPWR VGND sg13cmos5l_fill_2
XFILLER_30_72 VPWR VGND sg13cmos5l_decap_8
XFILLER_36_105 VPWR VGND sg13cmos5l_decap_8
XFILLER_17_341 VPWR VGND sg13cmos5l_fill_1
X_2712_ _2758_/B _2792_/B _2770_/A _2712_/C VPWR VGND sg13cmos5l_nor3_1
X_2643_ _2643_/Y _2641_/A _2641_/B _2642_/Y VPWR VGND sg13cmos5l_o21ai_1
X_2574_ _2581_/A _2575_/A _2574_/B VPWR VGND sg13cmos5l_nand2_1
XFILLER_35_28 VPWR VGND sg13cmos5l_fill_2
X_2008_ _2008_/Y _1816_/B _2010_/A VPWR VGND sg13cmos5l_nand2b_1
X_3126_ _3127_/C _3114_/Y _3126_/B _3126_/C VPWR VGND sg13cmos5l_nand3b_1
X_3057_ _3057_/Y _3145_/A _2307_/A _3052_/Y _3056_/A _3056_/Y VPWR VGND sg13cmos5l_a221oi_1
XFILLER_35_193 VPWR VGND sg13cmos5l_decap_8
XFILLER_18_149 VPWR VGND sg13cmos5l_decap_8
XFILLER_14_300 VPWR VGND sg13cmos5l_fill_1
XFILLER_41_196 VPWR VGND sg13cmos5l_decap_4
XFILLER_41_60 VPWR VGND sg13cmos5l_decap_8
XFILLER_41_82 VPWR VGND sg13cmos5l_decap_8
XFILLER_44_7 VPWR VGND sg13cmos5l_decap_4
X_2290_ _2290_/Y _3003_/A _2322_/A VPWR VGND sg13cmos5l_nor2_1
Xheichips26_heiscore_190 uio_oe[2] VPWR VGND sg13cmos5l_tielo
X_2626_ _2626_/X _2623_/A _2623_/B _2621_/X VPWR VGND sg13cmos5l_a21o_1
X_2557_ _2558_/D _2250_/A _2136_/Y _2557_/B1 VPWR VGND sg13cmos5l_o21ai_1
XFILLER_46_16 VPWR VGND sg13cmos5l_decap_8
XFILLER_46_38 VPWR VGND sg13cmos5l_decap_4
Xclkbuf_5_7__f_clk _3416_/CLK clkbuf_4_3_0_clk/X VPWR VGND sg13cmos5l_buf_8
X_2488_ _2489_/B _2435_/A _2175_/B _2270_/A VPWR VGND sg13cmos5l_a21oi_1
XFILLER_23_163 VPWR VGND sg13cmos5l_fill_2
X_3109_ _3109_/X _3190_/A _1892_/Y _3108_/Y VPWR VGND sg13cmos5l_a21o_1
XFILLER_11_325 VPWR VGND sg13cmos5l_decap_8
XFILLER_14_196 VPWR VGND sg13cmos5l_decap_8
X_1790_ _2351_/D _1795_/A _2244_/A _2244_/B VPWR VGND sg13cmos5l_or3_1
X_3391_ _3391_/Q _3394_/CLK _3391_/D fanout178/X VPWR VGND sg13cmos5l_dfrbpq_1
X_2411_ _2518_/B _2450_/A _2446_/D VPWR VGND sg13cmos5l_nand2_1
XFILLER_37_222 VPWR VGND sg13cmos5l_decap_8
X_2273_ _2540_/C _2438_/A _2370_/A _2363_/B _2250_/A VPWR VGND sg13cmos5l_a22oi_1
X_2342_ _2342_/Y _1886_/B _2077_/Y _2340_/Y _2341_/Y _1908_/B VPWR VGND sg13cmos5l_a221oi_1
X_1988_ _1989_/D _2060_/C _1988_/B VPWR VGND sg13cmos5l_nand2_1
X_2609_ _2609_/Y _2608_/Y _2609_/B VPWR VGND sg13cmos5l_nand2b_1
XFILLER_43_214 VPWR VGND sg13cmos5l_fill_1
Xclkbuf_4_5_0_clk clkbuf_4_5_0_clk/X clkbuf_0_clk/X VPWR VGND sg13cmos5l_buf_8
XFILLER_47_92 VPWR VGND sg13cmos5l_decap_8
X_2960_ _2960_/Y _2960_/A _2960_/B VPWR VGND sg13cmos5l_xnor2_1
XFILLER_42_291 VPWR VGND sg13cmos5l_fill_1
X_1773_ _1852_/A _1773_/A _1991_/A VPWR VGND sg13cmos5l_or2_1
X_1842_ _1842_/Y _3065_/A _1836_/A _1855_/A _3046_/A VPWR VGND sg13cmos5l_a22oi_1
X_1911_ _2178_/B _3423_/Q _3424_/Q VPWR VGND sg13cmos5l_nor2b_1
X_2891_ _2899_/C _2893_/A _2893_/B VPWR VGND sg13cmos5l_or2_1
X_3374_ _3374_/Q _3376_/CLK _3374_/D fanout175/X VPWR VGND sg13cmos5l_dfrbpq_1
X_2187_ _2188_/C _2510_/C _2418_/A VPWR VGND sg13cmos5l_nand2b_1
X_2256_ _2388_/A _2256_/A _2558_/C VPWR VGND sg13cmos5l_nand2_1
X_2325_ _2325_/Y _1892_/Y _2319_/B _2317_/X _2319_/Y _2324_/Y VPWR VGND sg13cmos5l_a221oi_1
XFILLER_25_236 VPWR VGND sg13cmos5l_fill_2
XFILLER_0_324 VPWR VGND sg13cmos5l_fill_1
XFILLER_0_335 VPWR VGND sg13cmos5l_fill_2
X_2041_ _2042_/C _2041_/A _2072_/A _2072_/B _2041_/D VPWR VGND sg13cmos5l_nor4_1
X_2110_ _2111_/B _2902_/A _2926_/A _2926_/B _2902_/B VPWR VGND sg13cmos5l_nand4_1
X_3090_ _3146_/B _3269_/B _3144_/C _3144_/A VPWR VGND sg13cmos5l_o21ai_1
X_2943_ _2980_/A _2939_/A _2935_/C _2950_/B VPWR VGND sg13cmos5l_a21oi_1
X_1756_ _2092_/A _2032_/A _2023_/A _1934_/A _1937_/A VPWR VGND sg13cmos5l_nor4_1
X_1825_ _1825_/Y _1825_/A _1825_/B _1825_/C VPWR VGND sg13cmos5l_nor3_1
X_2874_ _2882_/B _2874_/A _2874_/B _2874_/C VPWR VGND sg13cmos5l_and3_1
X_1687_ _1687_/Y _1687_/A VPWR VGND sg13cmos5l_inv_1
X_2308_ _2308_/Y _1831_/B _2296_/B _2307_/Y VPWR VGND sg13cmos5l_o21ai_1
X_3426_ _3426_/Q clkload5/A _3426_/D fanout180/X VPWR VGND sg13cmos5l_dfrbpq_1
X_3357_ _3357_/Q _3364_/CLK _3357_/D fanout164/X VPWR VGND sg13cmos5l_dfrbpq_1
X_2239_ _2355_/B _2239_/A _2238_/Y VPWR VGND sg13cmos5l_nor2b_1
X_3288_ _3289_/B _3288_/A _3288_/B VPWR VGND sg13cmos5l_xnor2_1
XFILLER_0_154 VPWR VGND sg13cmos5l_fill_2
XFILLER_44_60 VPWR VGND sg13cmos5l_fill_1
X_2590_ _2591_/C _3276_/B _3293_/A VPWR VGND sg13cmos5l_and2_1
XFILLER_39_125 VPWR VGND sg13cmos5l_decap_8
XFILLER_5_65 VPWR VGND sg13cmos5l_fill_1
X_3211_ _3211_/Y _3387_/Q _2052_/A _2063_/C _3386_/Q VPWR VGND sg13cmos5l_a22oi_1
X_3142_ _3142_/Y _3159_/A _3142_/B VPWR VGND sg13cmos5l_nand2_1
XFILLER_39_136 VPWR VGND sg13cmos5l_fill_2
XFILLER_39_158 VPWR VGND sg13cmos5l_decap_8
X_2024_ _2024_/X _2024_/A _2024_/B VPWR VGND sg13cmos5l_or2_1
X_3073_ _3175_/A _3165_/A _3208_/A _3073_/C VPWR VGND sg13cmos5l_nand3_1
XFILLER_10_209 VPWR VGND sg13cmos5l_decap_8
XFILLER_40_18 VPWR VGND sg13cmos5l_decap_8
X_2926_ _2927_/B _2926_/A _2926_/B _2926_/C VPWR VGND sg13cmos5l_nand3_1
X_2857_ _2859_/B _3265_/B _3164_/C _2857_/C _3265_/C VPWR VGND sg13cmos5l_nand4_1
X_1739_ _1739_/X _2863_/B _3274_/B _1721_/Y VPWR VGND sg13cmos5l_a21o_1
X_1808_ _1808_/Y _1933_/B _3190_/B VPWR VGND sg13cmos5l_nand2_1
Xhold210 _3314_/D _1735_/Y VPWR VGND sg13cmos5l_dlygate4sd3_1
Xhold221 _2928_/A _3412_/Q VPWR VGND sg13cmos5l_dlygate4sd3_1
Xhold232 _3350_/D _2721_/Y VPWR VGND sg13cmos5l_dlygate4sd3_1
Xhold243 _2103_/D _3393_/Q VPWR VGND sg13cmos5l_dlygate4sd3_1
Xhold254 _2899_/B _3402_/Q VPWR VGND sg13cmos5l_dlygate4sd3_1
Xhold265 _3320_/D _3267_/X VPWR VGND sg13cmos5l_dlygate4sd3_1
Xhold276 hold276/X _3368_/Q VPWR VGND sg13cmos5l_dlygate4sd3_1
Xhold287 _3396_/D _2883_/Y VPWR VGND sg13cmos5l_dlygate4sd3_1
X_2788_ _2798_/B _3269_/B _3269_/C VPWR VGND sg13cmos5l_nor2_1
XFILLER_45_106 VPWR VGND sg13cmos5l_decap_8
XFILLER_45_117 VPWR VGND sg13cmos5l_fill_1
Xhold298 _2863_/B _3316_/Q VPWR VGND sg13cmos5l_dlygate4sd3_1
X_3409_ _3409_/Q _3410_/CLK _3409_/D fanout184/X VPWR VGND sg13cmos5l_dfrbpq_1
XFILLER_26_353 VPWR VGND sg13cmos5l_fill_1
XFILLER_30_51 VPWR VGND sg13cmos5l_decap_8
XFILLER_30_62 VPWR VGND sg13cmos5l_fill_1
XFILLER_17_320 VPWR VGND sg13cmos5l_decap_8
X_2711_ _2711_/Y _1690_/Y _2685_/Y _2710_/Y _2678_/Y VPWR VGND sg13cmos5l_a22oi_1
X_2642_ _2642_/Y _2642_/A _2664_/A VPWR VGND sg13cmos5l_nor2_1
X_2573_ _3292_/A _2573_/A _3288_/B VPWR VGND sg13cmos5l_xnor2_1
X_3125_ _3126_/C _3256_/A1 _1886_/B _3097_/Y _3120_/Y VPWR VGND sg13cmos5l_a22oi_1
XFILLER_23_301 VPWR VGND sg13cmos5l_decap_4
XFILLER_23_312 VPWR VGND sg13cmos5l_decap_8
XFILLER_27_128 VPWR VGND sg13cmos5l_decap_8
XFILLER_27_139 VPWR VGND sg13cmos5l_decap_8
XFILLER_35_150 VPWR VGND sg13cmos5l_decap_8
X_2007_ _2027_/A _2007_/A _2007_/B VPWR VGND sg13cmos5l_nor2_1
X_3056_ _3056_/Y _3056_/A _3056_/B VPWR VGND sg13cmos5l_nor2_1
X_2909_ _2909_/Y _2909_/A _2910_/B VPWR VGND sg13cmos5l_nand2_1
XFILLER_33_109 VPWR VGND sg13cmos5l_decap_8
XFILLER_14_312 VPWR VGND sg13cmos5l_decap_8
XFILLER_26_161 VPWR VGND sg13cmos5l_fill_2
XFILLER_41_142 VPWR VGND sg13cmos5l_decap_8
XFILLER_41_50 VPWR VGND sg13cmos5l_decap_4
XFILLER_32_120 VPWR VGND sg13cmos5l_decap_4
XFILLER_32_164 VPWR VGND sg13cmos5l_decap_8
Xheichips26_heiscore_191 uio_oe[3] VPWR VGND sg13cmos5l_tielo
X_2625_ _3335_/D _2622_/A _2671_/A2 _2624_/Y VPWR VGND sg13cmos5l_a21o_1
X_2556_ _2559_/C _2556_/A _2556_/B VPWR VGND sg13cmos5l_nand2_1
X_2487_ _2552_/A _2487_/A _2562_/B VPWR VGND sg13cmos5l_nor2b_1
X_3108_ _3108_/Y _3145_/A _2326_/A _3106_/A _3103_/Y _3107_/X VPWR VGND sg13cmos5l_a221oi_1
XFILLER_15_109 VPWR VGND sg13cmos5l_fill_1
XFILLER_23_153 VPWR VGND sg13cmos5l_decap_4
X_3039_ _3039_/Y _3041_/A _3039_/B VPWR VGND sg13cmos5l_nand2_1
XFILLER_36_50 VPWR VGND sg13cmos5l_fill_2
XFILLER_36_61 VPWR VGND sg13cmos5l_decap_8
X_3390_ _3390_/Q clkload5/A _3390_/D fanout178/X VPWR VGND sg13cmos5l_dfrbpq_1
X_2410_ _2429_/B _2774_/A _2522_/A _2410_/C _2476_/C VPWR VGND sg13cmos5l_nand4_1
X_2341_ _2341_/Y _2941_/A _2080_/Y _2077_/Y VPWR VGND sg13cmos5l_a21oi_1
X_2272_ _2276_/C _2556_/B _2466_/A VPWR VGND sg13cmos5l_nand2_1
XFILLER_32_19 VPWR VGND sg13cmos5l_decap_4
XFILLER_20_178 VPWR VGND sg13cmos5l_decap_4
X_1987_ _1989_/C _2594_/A _3329_/Q _2063_/A _2057_/B VPWR VGND sg13cmos5l_nor4_1
X_2608_ _2608_/Y _2607_/A _2607_/B _3286_/A VPWR VGND sg13cmos5l_o21ai_1
X_2539_ _2564_/A _2539_/A _2562_/B _2562_/C _2539_/D VPWR VGND sg13cmos5l_nand4_1
XFILLER_28_267 VPWR VGND sg13cmos5l_decap_8
XFILLER_28_278 VPWR VGND sg13cmos5l_decap_8
XFILLER_11_189 VPWR VGND sg13cmos5l_decap_8
Xfanout180 fanout180/X fanout181/X VPWR VGND sg13cmos5l_buf_1
XFILLER_19_278 VPWR VGND sg13cmos5l_fill_1
XFILLER_34_204 VPWR VGND sg13cmos5l_fill_1
XFILLER_34_215 VPWR VGND sg13cmos5l_fill_2
X_1910_ _2147_/B _3421_/Q _3422_/Q VPWR VGND sg13cmos5l_nand2_1
X_2890_ _2890_/Y _1695_/Y _2887_/Y _2893_/B VPWR VGND sg13cmos5l_o21ai_1
X_1772_ _1991_/A _2032_/A _2023_/A VPWR VGND sg13cmos5l_nand2_1
X_1841_ _1841_/Y _3066_/A _1838_/B _1840_/Y VPWR VGND sg13cmos5l_o21ai_1
XFILLER_26_0 VPWR VGND sg13cmos5l_fill_1
X_2324_ _2324_/Y _2007_/B _2286_/Y _2317_/A _2317_/B _2323_/Y VPWR VGND sg13cmos5l_a221oi_1
X_3373_ _3373_/Q _3373_/CLK _3373_/D fanout175/X VPWR VGND sg13cmos5l_dfrbpq_1
X_2186_ _2477_/A _2197_/B _2436_/B VPWR VGND sg13cmos5l_nor2_1
X_2255_ _2558_/C _2412_/A _2370_/B VPWR VGND sg13cmos5l_nand2_1
XFILLER_43_29 VPWR VGND sg13cmos5l_decap_8
XFILLER_31_218 VPWR VGND sg13cmos5l_fill_2
XFILLER_33_95 VPWR VGND sg13cmos5l_decap_8
X_2040_ _2041_/D _3229_/B _2040_/B _2040_/C _2040_/D VPWR VGND sg13cmos5l_nand4_1
X_2942_ _2942_/Y _2942_/A _2942_/B _2942_/C VPWR VGND sg13cmos5l_nand3_1
X_2873_ _2873_/Y _3390_/Q _3391_/Q _2873_/C _2873_/D VPWR VGND sg13cmos5l_nor4_1
X_1686_ _1686_/Y _1686_/A VPWR VGND sg13cmos5l_inv_1
X_1755_ _1758_/D _1934_/A _1937_/A VPWR VGND sg13cmos5l_nor2_1
X_1824_ _1825_/C _3190_/B _2307_/A VPWR VGND sg13cmos5l_xnor2_1
Xclkbuf_4_4_0_clk clkbuf_4_4_0_clk/X clkbuf_0_clk/X VPWR VGND sg13cmos5l_buf_8
X_2238_ _2238_/Y _3368_/Q _3429_/Q _2240_/A _2238_/D VPWR VGND sg13cmos5l_nand4_1
X_2307_ _2307_/Y _2307_/A _2326_/B VPWR VGND sg13cmos5l_nand2_1
X_3425_ _3425_/Q clkload5/A _3425_/D fanout173/X VPWR VGND sg13cmos5l_dfrbpq_1
X_3356_ _3356_/Q clkload3/A _3356_/D fanout169/X VPWR VGND sg13cmos5l_dfrbpq_1
X_3287_ _3326_/D _2575_/A _3294_/A2 _3286_/X VPWR VGND sg13cmos5l_a21o_1
X_2169_ _2728_/A _2763_/A _2734_/C VPWR VGND sg13cmos5l_and2_1
XFILLER_21_273 VPWR VGND sg13cmos5l_decap_8
XFILLER_12_262 VPWR VGND sg13cmos5l_decap_8
XFILLER_12_295 VPWR VGND sg13cmos5l_decap_8
XFILLER_8_233 VPWR VGND sg13cmos5l_decap_4
X_3210_ _3210_/Y _3164_/D _2063_/C _3209_/Y VPWR VGND sg13cmos5l_o21ai_1
X_3141_ _3142_/B _3168_/A _3141_/B VPWR VGND sg13cmos5l_nand2_1
X_2023_ _2024_/B _2023_/A _2023_/B VPWR VGND sg13cmos5l_nor2_1
X_3072_ _3073_/C _3121_/A _3168_/C _3199_/A VPWR VGND sg13cmos5l_or3_1
X_1807_ _1807_/Y _1855_/A _3059_/B VPWR VGND sg13cmos5l_nor2b_1
X_2925_ _2925_/Y _2925_/A _2925_/B _2925_/C VPWR VGND sg13cmos5l_nand3_1
X_2856_ _2858_/A _3265_/B _2855_/X _2806_/A VPWR VGND sg13cmos5l_o21ai_1
XFILLER_49_39 VPWR VGND sg13cmos5l_decap_8
X_1669_ _3003_/A _1669_/A VPWR VGND sg13cmos5l_inv_1
X_1738_ _1738_/X _1738_/A _3315_/Q VPWR VGND sg13cmos5l_or2_1
Xhold211 _2792_/A _3414_/Q VPWR VGND sg13cmos5l_dlygate4sd3_1
Xhold222 hold222/X _2930_/Y VPWR VGND sg13cmos5l_dlygate4sd3_1
Xhold233 _2908_/C _3405_/Q VPWR VGND sg13cmos5l_dlygate4sd3_1
Xhold244 _3393_/D _2876_/Y VPWR VGND sg13cmos5l_dlygate4sd3_1
Xhold255 hold255/X _2898_/Y VPWR VGND sg13cmos5l_dlygate4sd3_1
Xhold266 hold266/X _3359_/Q VPWR VGND sg13cmos5l_dlygate4sd3_1
Xhold277 _1683_/A _3354_/Q VPWR VGND sg13cmos5l_dlygate4sd3_1
Xhold288 hold288/X _3305_/Q VPWR VGND sg13cmos5l_dlygate4sd3_1
Xhold299 _3316_/D _1739_/X VPWR VGND sg13cmos5l_dlygate4sd3_1
X_3408_ _3408_/Q clkload6/A _3408_/D fanout184/X VPWR VGND sg13cmos5l_dfrbpq_1
X_2787_ _3269_/D _2807_/A _3144_/C VPWR VGND sg13cmos5l_nor2_1
XFILLER_45_129 VPWR VGND sg13cmos5l_decap_4
X_3339_ _3339_/Q _3342_/CLK _3339_/D fanout182/X VPWR VGND sg13cmos5l_dfrbpq_1
XFILLER_5_236 VPWR VGND sg13cmos5l_fill_1
XFILLER_5_269 VPWR VGND sg13cmos5l_fill_2
XFILLER_30_96 VPWR VGND sg13cmos5l_decap_8
XFILLER_44_151 VPWR VGND sg13cmos5l_fill_2
XFILLER_44_184 VPWR VGND sg13cmos5l_fill_2
XFILLER_44_195 VPWR VGND sg13cmos5l_fill_1
X_2710_ _2710_/Y _2751_/A _2710_/B _2710_/C _2710_/D VPWR VGND sg13cmos5l_nand4_1
X_2641_ _2664_/A _2641_/A _2641_/B VPWR VGND sg13cmos5l_and2_1
X_2572_ _2574_/B _3323_/Q _3295_/Q VPWR VGND sg13cmos5l_nand2b_1
X_3124_ _3126_/B _3124_/A _3160_/A _3124_/C VPWR VGND sg13cmos5l_nor3_1
X_3055_ _3056_/B _3055_/A _3145_/A VPWR VGND sg13cmos5l_xor2_1
X_2006_ _2006_/Y _2032_/A _2006_/B VPWR VGND sg13cmos5l_nor2_1
X_2908_ _2910_/B _2908_/A _2908_/B _2908_/C _2908_/D VPWR VGND sg13cmos5l_or4_1
X_2839_ _2839_/Y _3224_/A hold325/X _2838_/Y VPWR VGND sg13cmos5l_a21oi_1
XFILLER_2_217 VPWR VGND sg13cmos5l_fill_1
XFILLER_18_107 VPWR VGND sg13cmos5l_fill_1
XFILLER_14_335 VPWR VGND sg13cmos5l_decap_8
XFILLER_22_390 VPWR VGND sg13cmos5l_fill_1
XFILLER_25_85 VPWR VGND sg13cmos5l_decap_4
XFILLER_2_67 VPWR VGND sg13cmos5l_fill_2
XFILLER_17_184 VPWR VGND sg13cmos5l_decap_4
XFILLER_32_143 VPWR VGND sg13cmos5l_decap_8
XFILLER_20_316 VPWR VGND sg13cmos5l_decap_8
XFILLER_32_198 VPWR VGND sg13cmos5l_fill_2
X_2624_ _2624_/Y _2642_/A _2624_/B VPWR VGND sg13cmos5l_nor2_1
Xheichips26_heiscore_192 uio_oe[4] VPWR VGND sg13cmos5l_tielo
X_2555_ _2560_/C _2555_/A _2555_/B _2555_/C _2555_/D VPWR VGND sg13cmos5l_nor4_1
X_2486_ _2568_/S _2486_/A _2486_/B _2563_/C _2486_/D VPWR VGND sg13cmos5l_and4_1
X_3107_ _3107_/X _3116_/C _3107_/B VPWR VGND sg13cmos5l_and2_1
X_3038_ _3310_/D _3038_/A VPWR VGND sg13cmos5l_inv_1
XFILLER_23_132 VPWR VGND sg13cmos5l_decap_8
XFILLER_23_187 VPWR VGND sg13cmos5l_fill_2
XFILLER_46_202 VPWR VGND sg13cmos5l_fill_2
X_2271_ _2466_/A _2376_/A _2389_/C VPWR VGND sg13cmos5l_nor2_1
X_2340_ _2340_/Y _2336_/Y _2338_/Y _2339_/Y VPWR VGND sg13cmos5l_o21ai_1
XFILLER_28_4 VPWR VGND sg13cmos5l_fill_2
XFILLER_20_135 VPWR VGND sg13cmos5l_fill_2
X_1986_ _2055_/B _2057_/B VPWR VGND sg13cmos5l_inv_1
Xclkbuf_5_15__f_clk _3383_/CLK clkbuf_4_7_0_clk/X VPWR VGND sg13cmos5l_buf_8
X_2607_ _2609_/B _2607_/A _2607_/B VPWR VGND sg13cmos5l_nand2_1
X_2538_ _2539_/D _2538_/A _2538_/B _2538_/C _2538_/D VPWR VGND sg13cmos5l_nor4_1
X_2469_ _2483_/A _2469_/A _2469_/B _2537_/A _2677_/C VPWR VGND sg13cmos5l_nand4_1
XFILLER_3_334 VPWR VGND sg13cmos5l_fill_2
XFILLER_19_224 VPWR VGND sg13cmos5l_decap_8
XFILLER_19_257 VPWR VGND sg13cmos5l_fill_1
Xfanout170 fanout170/X fanout171/X VPWR VGND sg13cmos5l_buf_1
Xfanout181 fanout181/X fanout188/X VPWR VGND sg13cmos5l_buf_1
X_1840_ _1840_/Y _2302_/A _1874_/B VPWR VGND sg13cmos5l_nand2_1
X_1771_ _1774_/B _2023_/A _1937_/A _3190_/B _1874_/B VPWR VGND sg13cmos5l_nand4_1
X_2254_ _2536_/B _2774_/A _2773_/C _2454_/A VPWR VGND sg13cmos5l_nand3_1
X_2323_ _2323_/Y _3298_/Q _2320_/B _2288_/Y _2010_/A _2322_/Y VPWR VGND sg13cmos5l_a221oi_1
X_3372_ _3372_/Q _3379_/CLK _3372_/D fanout177/X VPWR VGND sg13cmos5l_dfrbpq_1
X_2185_ _2418_/A _2401_/A _2248_/A VPWR VGND sg13cmos5l_nand2_1
X_1969_ _1970_/B _3333_/Q _1969_/B VPWR VGND sg13cmos5l_nor2_1
XFILLER_16_205 VPWR VGND sg13cmos5l_fill_1
XFILLER_16_249 VPWR VGND sg13cmos5l_decap_4
XFILLER_30_230 VPWR VGND sg13cmos5l_fill_1
XFILLER_30_285 VPWR VGND sg13cmos5l_fill_2
X_1823_ _1825_/B _3054_/A _1823_/B VPWR VGND sg13cmos5l_xnor2_1
X_2941_ _2942_/C _2941_/A _2941_/B _2984_/B _2941_/D VPWR VGND sg13cmos5l_nand4_1
X_2872_ _2872_/Y _2873_/C _2871_/C _2871_/Y VPWR VGND sg13cmos5l_a21oi_1
X_1685_ _1685_/Y _1685_/A VPWR VGND sg13cmos5l_inv_1
X_1754_ _2294_/B _2286_/A _2639_/A _2289_/B VPWR VGND sg13cmos5l_nand3_1
X_3424_ _3424_/Q clkload5/A _3424_/D fanout179/X VPWR VGND sg13cmos5l_dfrbpq_1
X_2237_ _2503_/A _3274_/A _1918_/D _2444_/B VPWR VGND sg13cmos5l_o21ai_1
X_2306_ _2306_/Y _3058_/B _2319_/B _2303_/X _2304_/Y _2305_/Y VPWR VGND sg13cmos5l_a221oi_1
X_3355_ _3355_/Q _3383_/CLK _3355_/D fanout170/X VPWR VGND sg13cmos5l_dfrbpq_1
X_3286_ _3286_/X _3286_/A _3286_/B _3286_/C VPWR VGND sg13cmos5l_and3_1
XFILLER_21_230 VPWR VGND sg13cmos5l_fill_1
X_2099_ _2099_/X _3425_/Q _2139_/B VPWR VGND sg13cmos5l_and2_1
X_2168_ _2734_/C _2769_/A _2769_/B VPWR VGND sg13cmos5l_nor2b_1
XFILLER_21_296 VPWR VGND sg13cmos5l_fill_1
XFILLER_28_41 VPWR VGND sg13cmos5l_fill_1
XFILLER_48_149 VPWR VGND sg13cmos5l_fill_2
X_3140_ _3140_/Y _3235_/A _3140_/B VPWR VGND sg13cmos5l_nor2_1
X_3071_ _3071_/Y _3065_/Y _3069_/Y _3070_/Y VPWR VGND sg13cmos5l_o21ai_1
X_2022_ _2022_/Y _2023_/A _2023_/B VPWR VGND sg13cmos5l_nand2_1
X_1806_ _3059_/B _1941_/B _1941_/C VPWR VGND sg13cmos5l_nand2_1
X_2924_ _2924_/Y _2920_/Y _2922_/Y _2925_/C VPWR VGND sg13cmos5l_o21ai_1
X_2855_ _2855_/X _3164_/C _2857_/C _3265_/C VPWR VGND sg13cmos5l_and3_1
X_2786_ _3091_/B _3137_/A _3138_/B VPWR VGND sg13cmos5l_nor2_1
XFILLER_49_18 VPWR VGND sg13cmos5l_decap_8
X_1668_ _3048_/A _3050_/B VPWR VGND sg13cmos5l_inv_1
X_1737_ _3428_/D _3415_/D _1737_/B VPWR VGND sg13cmos5l_and2_1
Xhold212 _1712_/B _3428_/Q VPWR VGND sg13cmos5l_dlygate4sd3_1
Xhold223 _3412_/D _2931_/Y VPWR VGND sg13cmos5l_dlygate4sd3_1
Xhold234 _2909_/A _2907_/Y VPWR VGND sg13cmos5l_dlygate4sd3_1
Xhold245 _2885_/C _3397_/Q VPWR VGND sg13cmos5l_dlygate4sd3_1
Xhold256 _3402_/D _2900_/Y VPWR VGND sg13cmos5l_dlygate4sd3_1
Xhold267 _3359_/D _2754_/X VPWR VGND sg13cmos5l_dlygate4sd3_1
Xhold278 _3354_/D _2741_/Y VPWR VGND sg13cmos5l_dlygate4sd3_1
Xhold289 _3005_/A _3004_/Y VPWR VGND sg13cmos5l_dlygate4sd3_1
X_3407_ _3407_/Q _3410_/CLK _3407_/D fanout185/X VPWR VGND sg13cmos5l_dfrbpq_1
X_3338_ _3338_/Q _3342_/CLK _3338_/D fanout182/X VPWR VGND sg13cmos5l_dfrbpq_1
XFILLER_26_300 VPWR VGND sg13cmos5l_decap_8
XFILLER_26_311 VPWR VGND sg13cmos5l_decap_4
XFILLER_38_160 VPWR VGND sg13cmos5l_fill_2
X_3269_ _3269_/Y _3269_/A _3269_/B _3269_/C _3269_/D VPWR VGND sg13cmos5l_nand4_1
XFILLER_39_40 VPWR VGND sg13cmos5l_decap_8
XFILLER_39_51 VPWR VGND sg13cmos5l_fill_1
Xclkbuf_4_3_0_clk clkbuf_4_3_0_clk/X clkbuf_0_clk/X VPWR VGND sg13cmos5l_buf_8
XFILLER_17_366 VPWR VGND sg13cmos5l_fill_1
XFILLER_29_171 VPWR VGND sg13cmos5l_decap_8
XFILLER_36_119 VPWR VGND sg13cmos5l_decap_8
XFILLER_44_130 VPWR VGND sg13cmos5l_decap_8
XFILLER_44_163 VPWR VGND sg13cmos5l_decap_8
XFILLER_44_174 VPWR VGND sg13cmos5l_fill_1
X_2640_ _2641_/B _2636_/A _2635_/A _2634_/Y VPWR VGND sg13cmos5l_o21ai_1
X_2571_ _2612_/B _3276_/A _3295_/Q VPWR VGND sg13cmos5l_nor2b_1
X_2005_ _2042_/B _2278_/A _2005_/B VPWR VGND sg13cmos5l_nand2_1
X_3123_ _3124_/C _3156_/A _3164_/D _3123_/C VPWR VGND sg13cmos5l_nand3_1
X_3054_ _3056_/A _3054_/A _3054_/B VPWR VGND sg13cmos5l_xor2_1
XFILLER_35_163 VPWR VGND sg13cmos5l_decap_8
X_2907_ _2907_/Y _2908_/C _2907_/B _2907_/C VPWR VGND sg13cmos5l_nand3_1
X_2838_ _2838_/Y _2838_/A _2852_/B VPWR VGND sg13cmos5l_nand2_1
X_2769_ _2770_/B _2769_/A _2769_/B _2769_/C VPWR VGND sg13cmos5l_nand3_1
XFILLER_26_152 VPWR VGND sg13cmos5l_fill_1
XFILLER_26_163 VPWR VGND sg13cmos5l_fill_1
XFILLER_41_96 VPWR VGND sg13cmos5l_fill_1
XFILLER_49_211 VPWR VGND sg13cmos5l_fill_2
XFILLER_17_141 VPWR VGND sg13cmos5l_fill_2
XFILLER_32_100 VPWR VGND sg13cmos5l_fill_1
XFILLER_32_177 VPWR VGND sg13cmos5l_decap_8
XFILLER_13_391 VPWR VGND sg13cmos5l_fill_1
XFILLER_9_340 VPWR VGND sg13cmos5l_decap_4
Xheichips26_heiscore_193 uio_oe[5] VPWR VGND sg13cmos5l_tielo
X_2623_ _2624_/B _2623_/A _2623_/B VPWR VGND sg13cmos5l_xnor2_1
X_2554_ _2560_/B _2554_/A _2554_/B _2554_/C VPWR VGND sg13cmos5l_nor3_1
X_2485_ _2486_/D _2485_/A _2485_/B _2485_/C _2485_/D VPWR VGND sg13cmos5l_nor4_1
X_3106_ _3107_/B _3106_/A _3106_/B VPWR VGND sg13cmos5l_nor2_1
X_3037_ _3038_/A _3032_/A _3039_/B _2997_/Y _3036_/Y VPWR VGND sg13cmos5l_a22oi_1
XFILLER_6_354 VPWR VGND sg13cmos5l_decap_8
XFILLER_42_7 VPWR VGND sg13cmos5l_decap_8
X_2270_ _2389_/C _2270_/A _2435_/A VPWR VGND sg13cmos5l_nor2_1
XFILLER_37_203 VPWR VGND sg13cmos5l_decap_4
X_1985_ _2057_/B _1767_/Y _1991_/A _2077_/A VPWR VGND sg13cmos5l_o21ai_1
X_2606_ _2607_/B _2606_/A _2606_/B VPWR VGND sg13cmos5l_xnor2_1
X_2537_ _2538_/D _2537_/A _2537_/B VPWR VGND sg13cmos5l_nand2_1
X_2468_ _2677_/C _2468_/A _2468_/B VPWR VGND sg13cmos5l_nor2_1
X_2399_ _2400_/C _2556_/B _2399_/B VPWR VGND sg13cmos5l_nand2_1
XFILLER_3_324 VPWR VGND sg13cmos5l_fill_2
XFILLER_34_239 VPWR VGND sg13cmos5l_fill_2
XFILLER_47_73 VPWR VGND sg13cmos5l_decap_4
Xfanout160 _2952_/A hold371/X VPWR VGND sg13cmos5l_buf_1
Xfanout171 fanout171/X fanout174/X VPWR VGND sg13cmos5l_buf_1
Xfanout182 fanout182/X fanout187/X VPWR VGND sg13cmos5l_buf_1
X_1770_ _1836_/A _2659_/A _1773_/A VPWR VGND sg13cmos5l_xnor2_1
Xclkbuf_5_21__f_clk clkload5/A clkbuf_4_10_0_clk/X VPWR VGND sg13cmos5l_buf_8
XFILLER_10_180 VPWR VGND sg13cmos5l_fill_1
XFILLER_40_4 VPWR VGND sg13cmos5l_fill_2
X_3371_ _3371_/Q _3389_/CLK _3371_/D fanout177/X VPWR VGND sg13cmos5l_dfrbpq_1
X_2184_ _2376_/A _2184_/A _2436_/B VPWR VGND sg13cmos5l_nor2_1
X_2253_ _2454_/A _2198_/B _2557_/B1 _2206_/A _2369_/A VPWR VGND sg13cmos5l_a22oi_1
X_2322_ _2322_/Y _2322_/A _2322_/B VPWR VGND sg13cmos5l_nor2_1
XFILLER_21_401 VPWR VGND sg13cmos5l_fill_2
XFILLER_40_209 VPWR VGND sg13cmos5l_decap_8
X_1899_ _1899_/Y _3115_/A _1900_/B VPWR VGND sg13cmos5l_xnor2_1
X_1968_ _1969_/B _2064_/A _2060_/B VPWR VGND sg13cmos5l_xnor2_1
XFILLER_16_217 VPWR VGND sg13cmos5l_decap_8
XFILLER_33_31 VPWR VGND sg13cmos5l_decap_8
XFILLER_33_53 VPWR VGND sg13cmos5l_fill_1
XFILLER_22_209 VPWR VGND sg13cmos5l_decap_8
X_2940_ _2941_/D _2952_/A _3101_/B _1897_/B VPWR VGND sg13cmos5l_a21oi_1
XFILLER_15_272 VPWR VGND sg13cmos5l_decap_4
X_1753_ _1753_/Y _1816_/A _3181_/A _1816_/B VPWR VGND sg13cmos5l_o21ai_1
X_1822_ _3058_/B _2307_/A VPWR VGND sg13cmos5l_inv_1
X_2871_ _2871_/Y _2873_/C _2932_/B _2871_/C VPWR VGND sg13cmos5l_nor3_1
X_1684_ _1684_/Y _1684_/A VPWR VGND sg13cmos5l_inv_1
X_3423_ _3423_/Q _3423_/CLK _3423_/D fanout180/X VPWR VGND sg13cmos5l_dfrbpq_1
X_3354_ _3354_/Q _3354_/CLK _3354_/D fanout170/X VPWR VGND sg13cmos5l_dfrbpq_1
X_2167_ _2167_/Y _2769_/A _2763_/A VPWR VGND sg13cmos5l_nand2b_1
X_2236_ _3421_/D _2539_/A _3275_/A _2236_/C _2354_/A VPWR VGND sg13cmos5l_nand4_1
X_2305_ _2305_/Y _2990_/B _2286_/Y _2303_/B _2303_/A _2293_/C VPWR VGND sg13cmos5l_a221oi_1
X_3285_ _3286_/C _3285_/A _3285_/B VPWR VGND sg13cmos5l_or2_1
X_2098_ _2139_/B _2098_/A _3427_/Q VPWR VGND sg13cmos5l_nor2b_1
XFILLER_0_179 VPWR VGND sg13cmos5l_fill_2
XFILLER_48_106 VPWR VGND sg13cmos5l_fill_1
XFILLER_28_97 VPWR VGND sg13cmos5l_decap_4
XFILLER_44_74 VPWR VGND sg13cmos5l_decap_4
XFILLER_44_96 VPWR VGND sg13cmos5l_decap_4
X_2021_ _2021_/X _2019_/Y _2020_/Y _2006_/Y VPWR VGND sg13cmos5l_a21o_1
X_3070_ _3070_/Y _3065_/A _3115_/B _3269_/A _3046_/A VPWR VGND sg13cmos5l_a22oi_1
X_2923_ _2925_/C _3409_/Q _2923_/B _2923_/C VPWR VGND sg13cmos5l_or3_1
X_1736_ _3429_/D _3415_/D _1736_/B _3418_/D _1736_/D VPWR VGND sg13cmos5l_nor4_1
X_1805_ _1941_/C _2302_/A _2302_/B _1663_/Y VPWR VGND sg13cmos5l_o21ai_1
Xhold213 _1713_/B _1735_/B VPWR VGND sg13cmos5l_dlygate4sd3_1
Xhold224 _2925_/A _3411_/Q VPWR VGND sg13cmos5l_dlygate4sd3_1
Xhold235 _3405_/D _2909_/Y VPWR VGND sg13cmos5l_dlygate4sd3_1
X_2854_ _3265_/C _3165_/A _3159_/A VPWR VGND sg13cmos5l_and2_1
X_2785_ _2812_/A _2849_/A _2785_/B VPWR VGND sg13cmos5l_nand2_1
X_1667_ _2990_/B _3008_/A VPWR VGND sg13cmos5l_inv_1
Xhold246 _2886_/A _2884_/Y VPWR VGND sg13cmos5l_dlygate4sd3_1
Xhold257 _2908_/A _3403_/Q VPWR VGND sg13cmos5l_dlygate4sd3_1
Xhold268 _1689_/A _3348_/Q VPWR VGND sg13cmos5l_dlygate4sd3_1
Xhold279 _2908_/B _3404_/Q VPWR VGND sg13cmos5l_dlygate4sd3_1
X_3406_ _3406_/Q _3412_/CLK _3406_/D fanout185/X VPWR VGND sg13cmos5l_dfrbpq_1
X_3337_ _3337_/Q clkload6/A _3337_/D fanout183/X VPWR VGND sg13cmos5l_dfrbpq_1
X_2219_ _2219_/Y _2196_/A _2195_/B _2274_/C VPWR VGND sg13cmos5l_a21oi_1
X_3268_ _3268_/Y _3268_/A _3268_/B VPWR VGND sg13cmos5l_nand2_1
X_3199_ _3199_/Y _3199_/A _3200_/B VPWR VGND sg13cmos5l_nand2_1
XFILLER_39_74 VPWR VGND sg13cmos5l_decap_4
XFILLER_17_334 VPWR VGND sg13cmos5l_decap_8
XFILLER_29_194 VPWR VGND sg13cmos5l_decap_4
XFILLER_44_153 VPWR VGND sg13cmos5l_fill_1
X_2570_ _2570_/Y _2570_/A _3286_/A _2770_/A _2748_/A VPWR VGND sg13cmos5l_nor4_1
X_3122_ _3160_/A _3168_/A _3165_/C VPWR VGND sg13cmos5l_nand2_1
X_2004_ _2005_/B _2278_/B _2230_/B VPWR VGND sg13cmos5l_nor2_1
X_3053_ _3053_/Y _3054_/A _3146_/A VPWR VGND sg13cmos5l_nor2_1
XFILLER_23_326 VPWR VGND sg13cmos5l_decap_4
XFILLER_35_186 VPWR VGND sg13cmos5l_decap_8
X_2906_ _2906_/Y _2926_/C hold280/X _2907_/C VPWR VGND sg13cmos5l_o21ai_1
X_1719_ _2438_/A _3421_/Q _3422_/Q _2213_/A VPWR VGND sg13cmos5l_nor3_1
X_2837_ _3381_/D _2852_/B _2837_/B _2837_/C VPWR VGND sg13cmos5l_and3_1
X_2768_ _2768_/Y _2769_/A _2769_/C _2769_/B VPWR VGND sg13cmos5l_a21oi_1
X_2699_ _2699_/Y _2751_/A _2699_/B _2699_/C _2710_/C VPWR VGND sg13cmos5l_nand4_1
Xclkbuf_5_2__f_clk _3354_/CLK clkbuf_4_1_0_clk/X VPWR VGND sg13cmos5l_buf_8
XFILLER_41_189 VPWR VGND sg13cmos5l_decap_8
XFILLER_41_75 VPWR VGND sg13cmos5l_decap_8
XFILLER_1_252 VPWR VGND sg13cmos5l_fill_1
XFILLER_9_363 VPWR VGND sg13cmos5l_decap_4
Xheichips26_heiscore_194 uio_oe[6] VPWR VGND sg13cmos5l_tielo
X_2622_ _2623_/B _2622_/A _2673_/B VPWR VGND sg13cmos5l_xor2_1
X_2553_ _2554_/C _2553_/A _2553_/B _2553_/C _2553_/D VPWR VGND sg13cmos5l_nand4_1
X_3105_ _3106_/B _3105_/A _3190_/A VPWR VGND sg13cmos5l_nor2_1
X_2484_ _2485_/D _2408_/Y _2484_/B VPWR VGND sg13cmos5l_nand2b_1
X_3036_ _3036_/Y _3036_/A _3036_/B VPWR VGND sg13cmos5l_xnor2_1
Xclkbuf_4_2_0_clk clkbuf_4_2_0_clk/X clkbuf_0_clk/X VPWR VGND sg13cmos5l_buf_8
XFILLER_46_204 VPWR VGND sg13cmos5l_fill_1
XFILLER_14_189 VPWR VGND sg13cmos5l_decap_8
XFILLER_36_75 VPWR VGND sg13cmos5l_fill_2
XFILLER_6_311 VPWR VGND sg13cmos5l_fill_1
XFILLER_6_322 VPWR VGND sg13cmos5l_decap_8
XFILLER_28_6 VPWR VGND sg13cmos5l_fill_1
XFILLER_37_215 VPWR VGND sg13cmos5l_decap_8
XFILLER_20_137 VPWR VGND sg13cmos5l_fill_1
X_1984_ _2040_/B _2057_/A _2003_/B VPWR VGND sg13cmos5l_nand2_1
X_2605_ _2607_/A _1963_/Y _2606_/B _2604_/Y VPWR VGND sg13cmos5l_o21ai_1
X_2536_ _2537_/B _2536_/A _2536_/B _2536_/C _2536_/D VPWR VGND sg13cmos5l_nor4_1
X_2467_ _2537_/A _2467_/A _2520_/C _2467_/C _2467_/D VPWR VGND sg13cmos5l_nor4_1
XFILLER_28_215 VPWR VGND sg13cmos5l_fill_1
X_2398_ _2526_/A _3274_/A _2444_/C _2503_/A VPWR VGND sg13cmos5l_a21oi_1
X_3019_ _3021_/A _3019_/A _3041_/B VPWR VGND sg13cmos5l_xnor2_1
XFILLER_22_77 VPWR VGND sg13cmos5l_fill_2
XFILLER_3_336 VPWR VGND sg13cmos5l_fill_1
Xfanout150 _3054_/A _3307_/Q VPWR VGND sg13cmos5l_buf_1
Xfanout161 _3101_/B _3297_/Q VPWR VGND sg13cmos5l_buf_1
Xfanout172 fanout172/X fanout174/X VPWR VGND sg13cmos5l_buf_1
Xfanout183 fanout183/X fanout186/X VPWR VGND sg13cmos5l_buf_1
XFILLER_47_41 VPWR VGND sg13cmos5l_decap_8
XFILLER_47_85 VPWR VGND sg13cmos5l_decap_8
XFILLER_30_402 VPWR VGND sg13cmos5l_fill_2
X_2321_ _2322_/B _1816_/B _2010_/A _3296_/Q VPWR VGND sg13cmos5l_o21ai_1
X_3370_ _3370_/Q _3389_/CLK _3370_/D fanout177/X VPWR VGND sg13cmos5l_dfrbpq_1
X_2183_ _2510_/C _2412_/B _2265_/B VPWR VGND sg13cmos5l_and2_1
X_2252_ _2554_/A _3026_/B _2468_/A VPWR VGND sg13cmos5l_or2_1
X_1898_ _1898_/Y _3180_/B _1896_/X _1894_/Y VPWR VGND sg13cmos5l_o21ai_1
X_1967_ _3233_/B _1981_/C _1966_/Y VPWR VGND sg13cmos5l_nor2b_1
XFILLER_0_317 VPWR VGND sg13cmos5l_decap_4
X_2519_ _2534_/A _2524_/A _2524_/B VPWR VGND sg13cmos5l_nor2_1
XFILLER_24_262 VPWR VGND sg13cmos5l_fill_2
XFILLER_15_295 VPWR VGND sg13cmos5l_fill_1
X_2870_ _2870_/Y _2870_/A _2870_/B VPWR VGND sg13cmos5l_nand2_1
XFILLER_30_287 VPWR VGND sg13cmos5l_fill_1
X_1683_ _3157_/A _1683_/A VPWR VGND sg13cmos5l_inv_1
X_1752_ _2094_/A _3333_/Q _2063_/A VPWR VGND sg13cmos5l_nand2_1
X_1821_ _2307_/A _3055_/A _3014_/A VPWR VGND sg13cmos5l_xor2_1
X_2304_ _2304_/Y _3055_/A _2319_/B VPWR VGND sg13cmos5l_xnor2_1
X_3422_ _3422_/Q _3422_/CLK _3422_/D fanout178/X VPWR VGND sg13cmos5l_dfrbpq_1
X_3353_ _3353_/Q _3354_/CLK _3353_/D fanout165/X VPWR VGND sg13cmos5l_dfrbpq_1
X_3284_ _3325_/D _1975_/A _3294_/A2 _3283_/Y VPWR VGND sg13cmos5l_a21o_1
X_2097_ _2407_/A _2094_/A _2094_/B _2096_/X VPWR VGND sg13cmos5l_a21oi_1
X_2166_ _2166_/Y _2750_/S _2694_/A VPWR VGND sg13cmos5l_nor2_1
X_2235_ _2354_/A _2235_/A _2992_/B VPWR VGND sg13cmos5l_nor2b_1
X_2999_ _3304_/D _3003_/A _3023_/A _2996_/Y VPWR VGND sg13cmos5l_a21oi_1
XFILLER_12_221 VPWR VGND sg13cmos5l_fill_1
XFILLER_28_76 VPWR VGND sg13cmos5l_decap_8
XFILLER_44_31 VPWR VGND sg13cmos5l_fill_1
XFILLER_44_42 VPWR VGND sg13cmos5l_decap_8
XFILLER_12_276 VPWR VGND sg13cmos5l_decap_4
XFILLER_39_118 VPWR VGND sg13cmos5l_decap_8
X_2020_ _2020_/Y _2031_/B2 _1897_/Y _2006_/B _2032_/A VPWR VGND sg13cmos5l_a22oi_1
X_2922_ _2922_/Y _2923_/B _2925_/B VPWR VGND sg13cmos5l_nand2_1
X_2853_ _3387_/D _3164_/C _2852_/C _2852_/Y VPWR VGND sg13cmos5l_o21ai_1
X_1666_ _3015_/A _3014_/A VPWR VGND sg13cmos5l_inv_1
X_1735_ _1735_/Y _1735_/A _1735_/B VPWR VGND sg13cmos5l_nor2_1
X_1804_ _1804_/Y _1855_/A VPWR VGND sg13cmos5l_inv_1
Xhold214 _2929_/A _3413_/Q VPWR VGND sg13cmos5l_dlygate4sd3_1
Xhold225 _2927_/A _2925_/Y VPWR VGND sg13cmos5l_dlygate4sd3_1
Xhold236 _2917_/A _3408_/Q VPWR VGND sg13cmos5l_dlygate4sd3_1
Xhold247 _3397_/D _2886_/Y VPWR VGND sg13cmos5l_dlygate4sd3_1
Xhold258 _3403_/D _2903_/Y VPWR VGND sg13cmos5l_dlygate4sd3_1
Xhold269 _3348_/D _2708_/Y VPWR VGND sg13cmos5l_dlygate4sd3_1
X_2784_ _2785_/B _3164_/C _3164_/D _3124_/A _2784_/D VPWR VGND sg13cmos5l_nor4_1
X_3405_ _3405_/Q _3412_/CLK _3405_/D fanout185/X VPWR VGND sg13cmos5l_dfrbpq_1
X_3336_ _3336_/Q _3422_/CLK _3336_/D fanout178/X VPWR VGND sg13cmos5l_dfrbpq_1
X_3267_ _3267_/X hold264/X _3268_/B _3266_/Y VPWR VGND sg13cmos5l_a21o_1
XFILLER_26_346 VPWR VGND sg13cmos5l_fill_1
X_2149_ _2149_/Y _3426_/Q _2150_/B VPWR VGND sg13cmos5l_nor2b_1
X_2218_ _2523_/A _2401_/B _2415_/A _2363_/B _2179_/B VPWR VGND sg13cmos5l_a22oi_1
X_3198_ _3200_/B _3324_/Q _3380_/Q VPWR VGND sg13cmos5l_or2_1
XFILLER_32_305 VPWR VGND sg13cmos5l_fill_2
X_3121_ _3165_/C _3121_/A _3168_/C VPWR VGND sg13cmos5l_xor2_1
XFILLER_23_305 VPWR VGND sg13cmos5l_fill_2
XFILLER_35_121 VPWR VGND sg13cmos5l_decap_8
XFILLER_35_143 VPWR VGND sg13cmos5l_decap_8
X_2003_ _2230_/B _2041_/A _2003_/B _2057_/B _2052_/A VPWR VGND sg13cmos5l_nor4_1
X_3052_ _3052_/Y _3008_/A _2807_/A _3051_/Y VPWR VGND sg13cmos5l_a21oi_1
X_2905_ _2907_/C _2908_/B _2926_/C VPWR VGND sg13cmos5l_nand2b_1
X_2836_ _2837_/C _3199_/A _2842_/B VPWR VGND sg13cmos5l_nand2b_1
X_1649_ _2659_/A _2032_/A VPWR VGND sg13cmos5l_inv_1
X_1718_ _2213_/A _3423_/Q _3424_/Q VPWR VGND sg13cmos5l_nand2_1
X_2767_ _2767_/Y _2769_/B _2767_/B VPWR VGND sg13cmos5l_nand2_1
X_2698_ _2710_/C _2750_/S _3360_/Q _2706_/A VPWR VGND sg13cmos5l_nand3_1
X_3319_ _3453_/A clkload0/A _3319_/D fanout163/X VPWR VGND sg13cmos5l_dfrbpq_1
XFILLER_14_305 VPWR VGND sg13cmos5l_decap_8
XFILLER_14_349 VPWR VGND sg13cmos5l_fill_1
XFILLER_26_198 VPWR VGND sg13cmos5l_fill_2
XFILLER_41_102 VPWR VGND sg13cmos5l_decap_8
XFILLER_41_113 VPWR VGND sg13cmos5l_fill_1
XFILLER_41_135 VPWR VGND sg13cmos5l_decap_8
XFILLER_41_168 VPWR VGND sg13cmos5l_fill_2
XFILLER_41_179 VPWR VGND sg13cmos5l_decap_4
XFILLER_41_43 VPWR VGND sg13cmos5l_decap_8
XFILLER_41_54 VPWR VGND sg13cmos5l_fill_2
XFILLER_17_143 VPWR VGND sg13cmos5l_fill_1
XFILLER_32_113 VPWR VGND sg13cmos5l_decap_8
XFILLER_13_371 VPWR VGND sg13cmos5l_fill_2
XFILLER_32_124 VPWR VGND sg13cmos5l_fill_1
XFILLER_32_157 VPWR VGND sg13cmos5l_decap_8
XFILLER_40_190 VPWR VGND sg13cmos5l_decap_4
Xheichips26_heiscore_195 uio_oe[7] VPWR VGND sg13cmos5l_tielo
X_2621_ _2621_/X _2622_/A _2673_/B VPWR VGND sg13cmos5l_and2_1
X_2552_ _2564_/B _2552_/A _2552_/B VPWR VGND sg13cmos5l_nand2_1
X_2483_ _2484_/B _2483_/A _2483_/B _2483_/C _2483_/D VPWR VGND sg13cmos5l_nor4_1
X_3104_ _3116_/C _3105_/A _3190_/A VPWR VGND sg13cmos5l_nand2_1
X_3035_ _3035_/Y _3035_/A _3036_/A _3035_/C VPWR VGND sg13cmos5l_nor3_1
XFILLER_11_308 VPWR VGND sg13cmos5l_fill_2
XFILLER_23_157 VPWR VGND sg13cmos5l_fill_1
X_2819_ _2820_/C _3190_/A _2827_/A _3091_/A VPWR VGND sg13cmos5l_o21ai_1
XFILLER_36_43 VPWR VGND sg13cmos5l_decap_8
XFILLER_46_238 VPWR VGND sg13cmos5l_fill_1
XFILLER_14_146 VPWR VGND sg13cmos5l_fill_2
XFILLER_14_179 VPWR VGND sg13cmos5l_fill_2
XFILLER_36_98 VPWR VGND sg13cmos5l_decap_8
XFILLER_6_367 VPWR VGND sg13cmos5l_fill_2
X_1983_ _1989_/B _2057_/A _2003_/B VPWR VGND sg13cmos5l_and2_1
X_2604_ _2604_/Y _2604_/A _2604_/B _2604_/C VPWR VGND sg13cmos5l_nand3_1
X_2535_ _2536_/D _2535_/A _2549_/B _2535_/C _2535_/D VPWR VGND sg13cmos5l_nand4_1
X_2466_ _2467_/D _2466_/A _2466_/B VPWR VGND sg13cmos5l_nand2_1
XFILLER_28_205 VPWR VGND sg13cmos5l_decap_4
XFILLER_28_238 VPWR VGND sg13cmos5l_fill_1
X_3018_ _3307_/D _3018_/A VPWR VGND sg13cmos5l_inv_1
X_2397_ _2444_/C _2397_/A _2397_/B _2397_/C _2397_/D VPWR VGND sg13cmos5l_nand4_1
Xfanout140 _1975_/A _2577_/A VPWR VGND sg13cmos5l_buf_1
Xfanout151 _3008_/A hold355/X VPWR VGND sg13cmos5l_buf_1
Xfanout162 _2010_/A _3297_/Q VPWR VGND sg13cmos5l_buf_1
Xfanout173 fanout173/X fanout174/X VPWR VGND sg13cmos5l_buf_1
Xfanout184 fanout184/X fanout186/X VPWR VGND sg13cmos5l_buf_1
X_2251_ _2468_/A _2251_/A _2493_/A VPWR VGND sg13cmos5l_nor2_1
X_2320_ _2320_/Y _3298_/Q _2320_/B VPWR VGND sg13cmos5l_nor2_1
X_2182_ _2558_/B _2438_/A _2412_/A _2450_/B _2380_/A _2400_/A VPWR VGND sg13cmos5l_a221oi_1
Xclkbuf_4_1_0_clk clkbuf_4_1_0_clk/X clkbuf_0_clk/X VPWR VGND sg13cmos5l_buf_8
XFILLER_18_282 VPWR VGND sg13cmos5l_fill_2
XFILLER_21_403 VPWR VGND sg13cmos5l_fill_1
X_1966_ _1966_/Y _2586_/A _2060_/B _2594_/A VPWR VGND sg13cmos5l_o21ai_1
X_1897_ _1897_/Y _1900_/B _1897_/B VPWR VGND sg13cmos5l_nand2_1
X_2518_ _2541_/C _2518_/A _2518_/B _2563_/A VPWR VGND sg13cmos5l_and3_1
X_2449_ _3426_/D _2449_/A _2449_/B _2449_/C _2449_/D VPWR VGND sg13cmos5l_nand4_1
XFILLER_17_89 VPWR VGND sg13cmos5l_fill_1
XFILLER_24_285 VPWR VGND sg13cmos5l_decap_4
XFILLER_33_11 VPWR VGND sg13cmos5l_decap_8
XFILLER_15_252 VPWR VGND sg13cmos5l_decap_8
X_1820_ _1825_/A _1812_/Y _1819_/Y _1813_/Y VPWR VGND sg13cmos5l_o21ai_1
X_1682_ _1682_/Y _1682_/A VPWR VGND sg13cmos5l_inv_1
X_1751_ _2063_/A _2002_/A _1965_/B VPWR VGND sg13cmos5l_nand2_1
X_3421_ _3421_/Q _3422_/CLK _3421_/D fanout178/X VPWR VGND sg13cmos5l_dfrbpq_1
X_2234_ _2992_/B input2/X input3/X _2544_/B VPWR VGND sg13cmos5l_nand3b_1
X_2303_ _2303_/X _2303_/A _2303_/B VPWR VGND sg13cmos5l_and2_1
X_3352_ _3352_/Q _3354_/CLK _3352_/D fanout170/X VPWR VGND sg13cmos5l_dfrbpq_1
X_3283_ _3283_/Y _3293_/A _3283_/B VPWR VGND sg13cmos5l_nor2_1
X_2096_ _2096_/X _2096_/A _2244_/C VPWR VGND sg13cmos5l_or2_1
X_2165_ _2694_/A _3360_/Q _2706_/A VPWR VGND sg13cmos5l_nand2_1
X_1949_ _1949_/Y _1949_/A _1949_/B _1949_/C _1949_/D VPWR VGND sg13cmos5l_nor4_1
X_2998_ _3023_/A _2998_/A _3006_/B VPWR VGND sg13cmos5l_or2_1
XFILLER_28_88 VPWR VGND sg13cmos5l_decap_4
XFILLER_29_333 VPWR VGND sg13cmos5l_fill_1
XFILLER_8_215 VPWR VGND sg13cmos5l_decap_4
XFILLER_8_226 VPWR VGND sg13cmos5l_decap_8
XFILLER_35_347 VPWR VGND sg13cmos5l_fill_2
XFILLER_47_185 VPWR VGND sg13cmos5l_fill_2
X_1803_ _1855_/A _1852_/A _1803_/B VPWR VGND sg13cmos5l_nand2_1
X_2921_ _2921_/Y _2919_/A _2923_/C _2919_/Y VPWR VGND sg13cmos5l_o21ai_1
X_2852_ _2852_/Y _3164_/C _2852_/B _2852_/C VPWR VGND sg13cmos5l_nand3_1
X_2783_ _2784_/D _3156_/A _3265_/B VPWR VGND sg13cmos5l_nand2_1
X_1665_ _1665_/Y _3055_/A VPWR VGND sg13cmos5l_inv_1
X_1734_ _1734_/X hold272/X _3274_/B _1721_/Y VPWR VGND sg13cmos5l_a21o_1
Xhold215 _3413_/D _2932_/Y VPWR VGND sg13cmos5l_dlygate4sd3_1
Xhold226 _3411_/D _2927_/Y VPWR VGND sg13cmos5l_dlygate4sd3_1
Xhold237 _2918_/A _2916_/Y VPWR VGND sg13cmos5l_dlygate4sd3_1
Xhold248 _1686_/A _3345_/Q VPWR VGND sg13cmos5l_dlygate4sd3_1
Xhold259 _1690_/A _3349_/Q VPWR VGND sg13cmos5l_dlygate4sd3_1
X_3404_ _3404_/Q clkload6/A _3404_/D fanout185/X VPWR VGND sg13cmos5l_dfrbpq_1
X_2217_ _2275_/B _2540_/B _2541_/A VPWR VGND sg13cmos5l_and2_1
X_3335_ _3335_/Q _3335_/CLK _3335_/D fanout183/X VPWR VGND sg13cmos5l_dfrbpq_1
X_3266_ _3266_/Y _3156_/D _3265_/Y _2779_/Y VPWR VGND sg13cmos5l_a21oi_1
X_3197_ _3215_/A _3265_/B _3212_/B VPWR VGND sg13cmos5l_nand2_1
XFILLER_38_196 VPWR VGND sg13cmos5l_fill_2
X_2079_ _2079_/Y _2079_/A _2078_/Y VPWR VGND sg13cmos5l_nor2b_1
X_2148_ _2499_/B _2351_/A _2433_/B VPWR VGND sg13cmos5l_nor2_1
XFILLER_30_89 VPWR VGND sg13cmos5l_decap_8
XFILLER_44_100 VPWR VGND sg13cmos5l_fill_2
XFILLER_44_144 VPWR VGND sg13cmos5l_decap_8
Xclkbuf_5_27__f_clk _3335_/CLK clkbuf_4_13_0_clk/X VPWR VGND sg13cmos5l_buf_8
X_3120_ _3120_/Y _3115_/Y _3118_/Y _3119_/Y VPWR VGND sg13cmos5l_o21ai_1
X_3051_ _3051_/Y _2990_/B _3247_/A1 _3049_/Y _3050_/Y VPWR VGND sg13cmos5l_a22oi_1
XFILLER_16_380 VPWR VGND sg13cmos5l_fill_2
XFILLER_35_177 VPWR VGND sg13cmos5l_decap_4
X_2002_ _2052_/A _2002_/A _2002_/B VPWR VGND sg13cmos5l_xnor2_1
X_2904_ _2904_/Y _2908_/B _2907_/B VPWR VGND sg13cmos5l_nand2_1
X_2835_ _2837_/B _2835_/A _3199_/A _2835_/C VPWR VGND sg13cmos5l_nand3_1
X_2766_ _3364_/D _2766_/A VPWR VGND sg13cmos5l_inv_1
X_1717_ _2178_/A _3421_/Q _3422_/Q VPWR VGND sg13cmos5l_nor2_1
X_3318_ _3452_/A _3365_/CLK _3318_/D fanout163/X VPWR VGND sg13cmos5l_dfrbpq_1
X_2697_ _2699_/C _2755_/A _2697_/B VPWR VGND sg13cmos5l_nand2_1
XFILLER_26_111 VPWR VGND sg13cmos5l_decap_8
X_3249_ _3249_/Y _3054_/B _2092_/D _3248_/Y VPWR VGND sg13cmos5l_o21ai_1
XFILLER_25_89 VPWR VGND sg13cmos5l_fill_1
XFILLER_41_125 VPWR VGND sg13cmos5l_decap_4
XFILLER_41_22 VPWR VGND sg13cmos5l_decap_8
XFILLER_49_225 VPWR VGND sg13cmos5l_fill_1
XFILLER_17_166 VPWR VGND sg13cmos5l_fill_2
XFILLER_17_177 VPWR VGND sg13cmos5l_fill_2
XFILLER_17_188 VPWR VGND sg13cmos5l_fill_2
XFILLER_20_309 VPWR VGND sg13cmos5l_decap_8
X_2620_ _2646_/B _2620_/A _3295_/Q VPWR VGND sg13cmos5l_nand2_1
Xheichips26_heiscore_196 uio_out[0] VPWR VGND sg13cmos5l_tielo
X_2551_ _2552_/B _2551_/A _2555_/D _2551_/C _2551_/D VPWR VGND sg13cmos5l_nor4_1
X_2482_ _2513_/A _2438_/A _2198_/B _2401_/B VPWR VGND sg13cmos5l_o21ai_1
X_3103_ _3103_/Y _2952_/A _2807_/A _3102_/Y VPWR VGND sg13cmos5l_a21oi_1
X_3034_ _3036_/B _3035_/A _3035_/C VPWR VGND sg13cmos5l_nor2_1
XFILLER_31_180 VPWR VGND sg13cmos5l_decap_8
XFILLER_31_191 VPWR VGND sg13cmos5l_fill_1
X_2818_ _2827_/A _2812_/B _2860_/A VPWR VGND sg13cmos5l_nand2b_1
X_2749_ _2749_/X hold294/X _2685_/Y _2748_/X VPWR VGND sg13cmos5l_a21o_1
Xclkbuf_5_10__f_clk _3376_/CLK clkbuf_4_5_0_clk/X VPWR VGND sg13cmos5l_buf_8
XFILLER_36_11 VPWR VGND sg13cmos5l_fill_2
XFILLER_36_77 VPWR VGND sg13cmos5l_fill_1
XFILLER_10_386 VPWR VGND sg13cmos5l_fill_1
X_1982_ _2003_/B _1981_/B _1981_/C _2054_/A VPWR VGND sg13cmos5l_a21o_1
XFILLER_13_180 VPWR VGND sg13cmos5l_fill_2
X_2603_ _3331_/D _2600_/A _3294_/A2 _2602_/Y VPWR VGND sg13cmos5l_a21o_1
X_2534_ _2536_/C _2534_/A _2534_/B _2534_/C VPWR VGND sg13cmos5l_nand3_1
XFILLER_47_0 VPWR VGND sg13cmos5l_decap_4
X_2465_ _2466_/B _2412_/A _2557_/B1 _2450_/B VPWR VGND sg13cmos5l_o21ai_1
X_2396_ _2397_/D _2396_/A _2396_/B VPWR VGND sg13cmos5l_nor2_1
X_3017_ _3017_/Y hold321/X _3006_/B _2997_/Y _3016_/Y VPWR VGND sg13cmos5l_a22oi_1
XFILLER_19_217 VPWR VGND sg13cmos5l_decap_8
XFILLER_47_32 VPWR VGND sg13cmos5l_fill_2
Xfanout130 _1816_/A _3335_/Q VPWR VGND sg13cmos5l_buf_1
Xfanout141 _3046_/A _3311_/Q VPWR VGND sg13cmos5l_buf_1
Xfanout152 _3050_/B _3305_/Q VPWR VGND sg13cmos5l_buf_1
Xfanout163 fanout163/X fanout164/X VPWR VGND sg13cmos5l_buf_1
Xfanout174 fanout174/X input1/X VPWR VGND sg13cmos5l_buf_1
Xfanout185 fanout185/X fanout186/X VPWR VGND sg13cmos5l_buf_1
XFILLER_6_110 VPWR VGND sg13cmos5l_fill_2
X_2250_ _2562_/B _2250_/A _2265_/B _2280_/C VPWR VGND sg13cmos5l_nand3_1
XFILLER_18_272 VPWR VGND sg13cmos5l_fill_2
X_2181_ _2400_/A _2510_/B _2522_/B VPWR VGND sg13cmos5l_nand2b_1
X_1965_ _2041_/A _3235_/B _1965_/B VPWR VGND sg13cmos5l_nand2b_1
X_1896_ _1896_/X _1900_/B _1897_/B VPWR VGND sg13cmos5l_and2_1
X_2517_ _2560_/A _2240_/A _2415_/A _2265_/B _2265_/A _2467_/C VPWR VGND sg13cmos5l_a221oi_1
X_2448_ _2449_/D _2457_/D _2448_/B VPWR VGND sg13cmos5l_nor2_1
X_2379_ _2380_/B _2132_/X _2379_/B VPWR VGND sg13cmos5l_nand2b_1
XFILLER_33_45 VPWR VGND sg13cmos5l_fill_2
XFILLER_33_67 VPWR VGND sg13cmos5l_decap_4
Xclkbuf_5_8__f_clk _3389_/CLK clkbuf_4_4_0_clk/X VPWR VGND sg13cmos5l_buf_8
XFILLER_47_356 VPWR VGND sg13cmos5l_fill_2
XFILLER_47_367 VPWR VGND sg13cmos5l_fill_1
XFILLER_15_231 VPWR VGND sg13cmos5l_fill_1
XFILLER_30_201 VPWR VGND sg13cmos5l_fill_1
X_1750_ _1981_/B _3331_/Q _3332_/Q VPWR VGND sg13cmos5l_nor2_1
X_1681_ _3150_/A _1681_/A VPWR VGND sg13cmos5l_inv_1
X_3420_ _3420_/Q _3422_/CLK _3420_/D fanout178/X VPWR VGND sg13cmos5l_dfrbpq_1
X_3351_ _3351_/Q _3354_/CLK _3351_/D fanout170/X VPWR VGND sg13cmos5l_dfrbpq_1
X_2164_ _2706_/A _2693_/B _3358_/Q VPWR VGND sg13cmos5l_nor2b_1
X_2233_ _2562_/A _2544_/B _2232_/Y _2235_/A VPWR VGND sg13cmos5l_a21oi_1
X_2302_ _2302_/Y _2302_/A _2302_/B _2302_/C VPWR VGND sg13cmos5l_nor3_1
X_3282_ _3283_/B _3282_/A _3282_/B VPWR VGND sg13cmos5l_xnor2_1
X_2095_ _2396_/A _2096_/A _2244_/C VPWR VGND sg13cmos5l_nor2_1
X_1879_ _1900_/B _3105_/A _2315_/A _2972_/A VPWR VGND sg13cmos5l_o21ai_1
X_1948_ _1949_/D _2084_/A _1665_/Y _1943_/Y VPWR VGND sg13cmos5l_a21o_1
X_2997_ _2997_/Y _2998_/A _3006_/B VPWR VGND sg13cmos5l_nor2_1
XFILLER_12_234 VPWR VGND sg13cmos5l_decap_4
XFILLER_8_249 VPWR VGND sg13cmos5l_fill_1
Xclkbuf_4_0_0_clk clkbuf_4_0_0_clk/X clkbuf_0_clk/X VPWR VGND sg13cmos5l_buf_8
XFILLER_39_109 VPWR VGND sg13cmos5l_decap_4
X_2920_ _2920_/Y _3409_/Q _2923_/C VPWR VGND sg13cmos5l_nor2_1
X_1733_ _1733_/Y _3414_/Q _2792_/B VPWR VGND sg13cmos5l_nand2_1
X_1802_ _1803_/B _2659_/A _1773_/A _2667_/A VPWR VGND sg13cmos5l_o21ai_1
X_2851_ _3386_/D _2852_/B _2852_/C _2851_/C VPWR VGND sg13cmos5l_and3_1
X_2782_ _2849_/A _3168_/A _2782_/B _2838_/A VPWR VGND sg13cmos5l_nor3_1
X_1664_ _2302_/A _3065_/A VPWR VGND sg13cmos5l_inv_1
Xhold205 _3313_/D _3314_/Q VPWR VGND sg13cmos5l_dlygate4sd3_1
Xhold216 _3268_/A _3450_/A VPWR VGND sg13cmos5l_dlygate4sd3_1
Xhold227 _3262_/A _3453_/A VPWR VGND sg13cmos5l_dlygate4sd3_1
Xhold238 _3408_/D _2918_/Y VPWR VGND sg13cmos5l_dlygate4sd3_1
Xhold249 _3345_/D _2695_/Y VPWR VGND sg13cmos5l_dlygate4sd3_1
X_3403_ _3403_/Q _3413_/CLK _3403_/D fanout185/X VPWR VGND sg13cmos5l_dfrbpq_1
X_3334_ _3334_/Q _3410_/CLK _3334_/D fanout183/X VPWR VGND sg13cmos5l_dfrbpq_1
XFILLER_26_315 VPWR VGND sg13cmos5l_fill_1
XFILLER_26_337 VPWR VGND sg13cmos5l_fill_1
XFILLER_38_131 VPWR VGND sg13cmos5l_decap_8
XFILLER_38_153 VPWR VGND sg13cmos5l_decap_8
XFILLER_38_175 VPWR VGND sg13cmos5l_decap_4
XFILLER_38_186 VPWR VGND sg13cmos5l_fill_2
X_2147_ _2433_/B _2147_/A _2147_/B VPWR VGND sg13cmos5l_or2_1
X_2216_ _2541_/A _2216_/A _2363_/B VPWR VGND sg13cmos5l_nand2_1
X_3265_ _3265_/Y _3265_/A _3265_/B _3265_/C VPWR VGND sg13cmos5l_nor3_1
X_3196_ _3259_/B _3256_/A1 _1905_/B _3195_/Y VPWR VGND sg13cmos5l_o21ai_1
X_2078_ _2078_/Y _2665_/A1 _2081_/B _2023_/A VPWR VGND sg13cmos5l_o21ai_1
XFILLER_30_35 VPWR VGND sg13cmos5l_decap_8
XFILLER_30_79 VPWR VGND sg13cmos5l_decap_4
XFILLER_39_33 VPWR VGND sg13cmos5l_decap_8
XFILLER_29_142 VPWR VGND sg13cmos5l_decap_8
XFILLER_44_123 VPWR VGND sg13cmos5l_decap_8
X_2001_ _2002_/B _2594_/A _3288_/A _2051_/B _2046_/C VPWR VGND sg13cmos5l_nand4_1
X_3050_ _3050_/Y _3048_/B _3050_/B VPWR VGND sg13cmos5l_nand2b_1
XFILLER_16_370 VPWR VGND sg13cmos5l_decap_4
X_2903_ _2903_/Y _2908_/A _2908_/D _2901_/Y VPWR VGND sg13cmos5l_o21ai_1
XFILLER_31_384 VPWR VGND sg13cmos5l_fill_2
X_1716_ _1716_/Y _2098_/A _1924_/B VPWR VGND sg13cmos5l_nand2b_1
X_2834_ _3380_/D _2791_/B _3268_/B _2835_/A VPWR VGND sg13cmos5l_mux2_1
X_2765_ _2766_/A _2769_/A _2767_/B _2726_/X _2770_/A VPWR VGND sg13cmos5l_a22oi_1
X_2696_ _2697_/B _2750_/S _2705_/B VPWR VGND sg13cmos5l_and2_1
X_3317_ _3451_/A _3364_/CLK _3317_/D fanout163/X VPWR VGND sg13cmos5l_dfrbpq_1
XFILLER_26_145 VPWR VGND sg13cmos5l_decap_8
X_3248_ _3248_/Y _2807_/A _2286_/Y _3246_/Y _3247_/Y VPWR VGND sg13cmos5l_a22oi_1
X_3179_ _3179_/Y _3179_/A _3179_/B _3179_/C _3222_/A VPWR VGND sg13cmos5l_nor4_1
XFILLER_41_67 VPWR VGND sg13cmos5l_fill_2
XFILLER_41_89 VPWR VGND sg13cmos5l_decap_8
XFILLER_13_373 VPWR VGND sg13cmos5l_fill_1
XFILLER_9_322 VPWR VGND sg13cmos5l_decap_8
XFILLER_9_333 VPWR VGND sg13cmos5l_decap_8
XFILLER_9_344 VPWR VGND sg13cmos5l_fill_2
Xheichips26_heiscore_197 uio_out[1] VPWR VGND sg13cmos5l_tielo
X_2550_ _2551_/D _2550_/A _2550_/B _2550_/C _2550_/D VPWR VGND sg13cmos5l_nand4_1
XFILLER_49_4 VPWR VGND sg13cmos5l_decap_8
X_2481_ _2483_/D _2549_/A _2496_/A _2553_/C _2481_/D VPWR VGND sg13cmos5l_nand4_1
X_3102_ _3102_/Y _2007_/B _3247_/A1 _3100_/X _3101_/Y VPWR VGND sg13cmos5l_a22oi_1
X_3033_ _3035_/C _3033_/A _3033_/B VPWR VGND sg13cmos5l_and2_1
X_2817_ _2821_/C _3138_/A _3137_/A _2817_/C VPWR VGND sg13cmos5l_nand3_1
X_2748_ _2748_/X _2748_/A _2748_/B VPWR VGND sg13cmos5l_and2_1
X_2679_ _2682_/C _3358_/Q _2750_/S VPWR VGND sg13cmos5l_nor2_1
XFILLER_46_218 VPWR VGND sg13cmos5l_fill_1
XFILLER_6_369 VPWR VGND sg13cmos5l_fill_1
X_1981_ _2057_/A _2054_/A _1981_/B _1981_/C VPWR VGND sg13cmos5l_nand3_1
X_2602_ _2602_/Y _2599_/Y _2604_/C _2601_/Y VPWR VGND sg13cmos5l_a21oi_1
X_2533_ _2534_/C _1924_/B _2412_/B _2498_/B VPWR VGND sg13cmos5l_a21oi_1
XFILLER_3_60 VPWR VGND sg13cmos5l_fill_2
X_2464_ _2467_/C _2499_/C _2464_/B VPWR VGND sg13cmos5l_nand2b_1
X_2395_ _2456_/A _2477_/A _2554_/A _2461_/B VPWR VGND sg13cmos5l_nor3_1
X_3016_ _3016_/Y _3016_/A _3016_/B VPWR VGND sg13cmos5l_xnor2_1
XFILLER_11_118 VPWR VGND sg13cmos5l_fill_2
XFILLER_11_129 VPWR VGND sg13cmos5l_fill_1
Xfanout120 _2653_/A _2031_/B2 VPWR VGND sg13cmos5l_buf_1
Xfanout131 _2622_/A hold357/X VPWR VGND sg13cmos5l_buf_1
XFILLER_47_22 VPWR VGND sg13cmos5l_decap_4
XFILLER_47_55 VPWR VGND sg13cmos5l_decap_4
XFILLER_47_66 VPWR VGND sg13cmos5l_decap_8
XFILLER_47_99 VPWR VGND sg13cmos5l_decap_8
Xfanout142 _3041_/A hold340/X VPWR VGND sg13cmos5l_buf_1
Xfanout153 _2984_/A hold379/X VPWR VGND sg13cmos5l_buf_1
Xfanout164 fanout164/X fanout169/X VPWR VGND sg13cmos5l_buf_1
Xfanout175 fanout175/X fanout188/X VPWR VGND sg13cmos5l_buf_1
Xfanout186 fanout186/X fanout187/X VPWR VGND sg13cmos5l_buf_1
XFILLER_27_284 VPWR VGND sg13cmos5l_fill_2
XFILLER_42_243 VPWR VGND sg13cmos5l_fill_2
X_2180_ _2180_/Y _2450_/B _2363_/B VPWR VGND sg13cmos5l_nand2_1
XFILLER_18_240 VPWR VGND sg13cmos5l_decap_8
XFILLER_18_284 VPWR VGND sg13cmos5l_fill_1
X_1895_ _1897_/B _2972_/A _3105_/A _3098_/A VPWR VGND sg13cmos5l_or3_1
X_1964_ _3235_/B _2002_/A _1981_/C VPWR VGND sg13cmos5l_xnor2_1
X_2516_ _2549_/C _2516_/A _2464_/B VPWR VGND sg13cmos5l_nor2b_1
X_2447_ _2448_/B _2773_/C _2677_/B _2447_/C _2447_/D VPWR VGND sg13cmos5l_nand4_1
X_2378_ _2419_/A _2493_/B _2677_/A _2378_/C VPWR VGND sg13cmos5l_nand3_1
XFILLER_24_232 VPWR VGND sg13cmos5l_fill_1
X_1680_ _1680_/Y _1680_/A VPWR VGND sg13cmos5l_inv_1
X_2301_ _2314_/B _2299_/Y _2300_/Y _2302_/C VPWR VGND sg13cmos5l_a21o_1
X_3350_ _3350_/Q _3383_/CLK _3350_/D fanout165/X VPWR VGND sg13cmos5l_dfrbpq_1
XFILLER_31_4 VPWR VGND sg13cmos5l_fill_1
X_2163_ _2225_/C _2389_/A _2499_/C VPWR VGND sg13cmos5l_nor2_1
X_2232_ _2232_/Y input2/X input3/X VPWR VGND sg13cmos5l_nor2b_1
X_3281_ _3281_/X _3279_/B _3294_/A2 _3280_/Y VPWR VGND sg13cmos5l_a21o_1
XFILLER_21_246 VPWR VGND sg13cmos5l_decap_8
X_2094_ _2397_/A _2094_/A _2094_/B VPWR VGND sg13cmos5l_nand2_1
X_1878_ _1908_/A _2941_/A _1804_/Y _1876_/X _1877_/Y _1797_/Y VPWR VGND sg13cmos5l_a221oi_1
X_1947_ _1949_/C _2085_/A _3028_/A VPWR VGND sg13cmos5l_nor2_1
X_2996_ _2996_/Y _3003_/A _3006_/B VPWR VGND sg13cmos5l_nor2_1
XFILLER_44_56 VPWR VGND sg13cmos5l_decap_4
XFILLER_44_67 VPWR VGND sg13cmos5l_decap_8
XFILLER_44_78 VPWR VGND sg13cmos5l_fill_1
XFILLER_44_89 VPWR VGND sg13cmos5l_decap_8
X_2850_ _2851_/C _3164_/D _2850_/B VPWR VGND sg13cmos5l_or2_1
X_1663_ _1663_/Y _3046_/A VPWR VGND sg13cmos5l_inv_1
X_1732_ _1737_/B _3416_/D _1732_/B VPWR VGND sg13cmos5l_nor2_1
X_1801_ _1941_/B _2302_/B _2992_/A VPWR VGND sg13cmos5l_or2_1
Xhold206 _3416_/D _3417_/Q VPWR VGND sg13cmos5l_dlygate4sd3_1
Xhold217 _1685_/A _3344_/Q VPWR VGND sg13cmos5l_dlygate4sd3_1
X_2781_ _2838_/A _3121_/A _2835_/A _3199_/A _2791_/B VPWR VGND sg13cmos5l_nand4_1
Xhold228 _3044_/A _3451_/A VPWR VGND sg13cmos5l_dlygate4sd3_1
Xhold239 _1738_/A _3313_/Q VPWR VGND sg13cmos5l_dlygate4sd3_1
X_3402_ _3402_/Q _3402_/CLK _3402_/D fanout184/X VPWR VGND sg13cmos5l_dfrbpq_1
X_3333_ _3333_/Q _3427_/CLK _3333_/D fanout173/X VPWR VGND sg13cmos5l_dfrbpq_1
X_3264_ _3319_/D _2832_/B _3263_/X _3262_/Y VPWR VGND sg13cmos5l_o21ai_1
XFILLER_38_121 VPWR VGND sg13cmos5l_decap_4
XFILLER_38_198 VPWR VGND sg13cmos5l_fill_1
X_2077_ _2077_/Y _2077_/A _2079_/A VPWR VGND sg13cmos5l_xnor2_1
X_2146_ _2205_/B _2147_/A _2147_/B VPWR VGND sg13cmos5l_nor2_1
X_2215_ _2540_/B _2401_/B _2370_/B VPWR VGND sg13cmos5l_nand2_1
X_3195_ _3195_/Y _3269_/A _1804_/Y _3193_/Y _3194_/Y VPWR VGND sg13cmos5l_a22oi_1
X_2979_ _2980_/B _2979_/A _2979_/B VPWR VGND sg13cmos5l_or2_1
XFILLER_30_58 VPWR VGND sg13cmos5l_decap_4
XFILLER_29_121 VPWR VGND sg13cmos5l_decap_8
XFILLER_39_12 VPWR VGND sg13cmos5l_decap_8
XFILLER_39_67 VPWR VGND sg13cmos5l_decap_8
XFILLER_17_327 VPWR VGND sg13cmos5l_decap_8
XFILLER_25_371 VPWR VGND sg13cmos5l_fill_1
XFILLER_29_198 VPWR VGND sg13cmos5l_fill_1
X_2000_ _2062_/B _3288_/A _2051_/B _2046_/C VPWR VGND sg13cmos5l_nand3_1
XFILLER_23_319 VPWR VGND sg13cmos5l_decap_8
XFILLER_35_157 VPWR VGND sg13cmos5l_fill_1
X_2902_ _2926_/C _2902_/A _2902_/B _2902_/C VPWR VGND sg13cmos5l_and3_1
X_2833_ _2842_/B _2835_/A _2835_/C VPWR VGND sg13cmos5l_nand2_1
X_1715_ _1715_/Y _3427_/Q _3425_/Q _2098_/A VPWR VGND sg13cmos5l_nor3_1
X_2764_ _3363_/D _2740_/A _2722_/A _2763_/Y VPWR VGND sg13cmos5l_o21ai_1
X_2695_ _2695_/Y _1686_/Y _2757_/A2 _2694_/Y _2678_/Y VPWR VGND sg13cmos5l_a22oi_1
X_3316_ _3316_/Q _3422_/CLK _3316_/D fanout178/X VPWR VGND sg13cmos5l_dfrbpq_1
X_3247_ _3247_/Y _3247_/A1 _2320_/B _2288_/Y _3048_/B VPWR VGND sg13cmos5l_a22oi_1
XFILLER_14_319 VPWR VGND sg13cmos5l_decap_4
X_2129_ _2428_/A _2240_/A _2216_/A VPWR VGND sg13cmos5l_nand2_1
X_3178_ _3222_/A _3178_/A _3178_/B VPWR VGND sg13cmos5l_nand2_1
XFILLER_22_330 VPWR VGND sg13cmos5l_decap_4
XFILLER_41_149 VPWR VGND sg13cmos5l_fill_2
XFILLER_13_341 VPWR VGND sg13cmos5l_fill_1
XFILLER_17_168 VPWR VGND sg13cmos5l_fill_1
XFILLER_9_301 VPWR VGND sg13cmos5l_fill_2
XFILLER_9_312 VPWR VGND sg13cmos5l_fill_2
XFILLER_9_356 VPWR VGND sg13cmos5l_decap_8
XFILLER_9_367 VPWR VGND sg13cmos5l_fill_2
Xheichips26_heiscore_198 uio_out[2] VPWR VGND sg13cmos5l_tielo
X_2480_ _2481_/D _2516_/A _2510_/A _2559_/B _2480_/D VPWR VGND sg13cmos5l_nor4_1
X_3101_ _3101_/Y _3048_/B _3101_/B VPWR VGND sg13cmos5l_nand2b_1
X_3032_ _3036_/A _3032_/A _3041_/B VPWR VGND sg13cmos5l_xnor2_1
XFILLER_23_149 VPWR VGND sg13cmos5l_fill_1
XFILLER_31_160 VPWR VGND sg13cmos5l_decap_4
X_2816_ _3375_/D _3137_/A _2813_/Y _2815_/Y VPWR VGND sg13cmos5l_a21oi_1
X_2747_ _2748_/B _2705_/B _2691_/B _2746_/X VPWR VGND sg13cmos5l_o21ai_1
X_2678_ _2678_/Y _1731_/Y _2934_/B _2677_/Y VPWR VGND sg13cmos5l_a21oi_1
XFILLER_36_24 VPWR VGND sg13cmos5l_fill_2
XFILLER_36_35 VPWR VGND sg13cmos5l_fill_2
XFILLER_39_271 VPWR VGND sg13cmos5l_fill_2
XFILLER_36_68 VPWR VGND sg13cmos5l_decap_8
XFILLER_22_171 VPWR VGND sg13cmos5l_fill_2
XFILLER_13_193 VPWR VGND sg13cmos5l_decap_8
X_1980_ _2042_/A _1980_/A _2041_/A _1980_/C _1980_/D VPWR VGND sg13cmos5l_nor4_1
X_2601_ _2601_/Y _2599_/Y _2604_/C _3286_/A VPWR VGND sg13cmos5l_o21ai_1
X_2532_ _2534_/B _2248_/A _2412_/B _2498_/A VPWR VGND sg13cmos5l_a21oi_1
X_2463_ _2469_/B _2198_/B _2401_/B _2219_/Y VPWR VGND sg13cmos5l_a21oi_1
X_3015_ _3016_/B _3015_/A _3028_/B VPWR VGND sg13cmos5l_xnor2_1
X_2394_ _3423_/D _2461_/B _2486_/A _2394_/C VPWR VGND sg13cmos5l_nand3b_1
XFILLER_0_8 VPWR VGND sg13cmos5l_fill_1
Xfanout110 _2763_/A hold356/X VPWR VGND sg13cmos5l_buf_1
Xfanout121 _2031_/B2 _3340_/Q VPWR VGND sg13cmos5l_buf_1
Xfanout132 _3181_/A _3334_/Q VPWR VGND sg13cmos5l_buf_1
Xfanout143 _3065_/A _3310_/Q VPWR VGND sg13cmos5l_buf_1
Xfanout154 _3115_/A _3302_/Q VPWR VGND sg13cmos5l_buf_1
Xfanout165 fanout165/X fanout169/X VPWR VGND sg13cmos5l_buf_1
XFILLER_27_241 VPWR VGND sg13cmos5l_decap_4
XFILLER_47_34 VPWR VGND sg13cmos5l_fill_1
Xfanout176 fanout176/X fanout188/X VPWR VGND sg13cmos5l_buf_1
Xfanout187 fanout187/X fanout188/X VPWR VGND sg13cmos5l_buf_1
XFILLER_2_340 VPWR VGND sg13cmos5l_fill_1
XFILLER_18_296 VPWR VGND sg13cmos5l_decap_4
X_1894_ _1894_/Y _3190_/B _2326_/A VPWR VGND sg13cmos5l_nand2_1
X_1963_ _1963_/Y _2594_/A _2586_/A _2573_/A _3331_/Q VPWR VGND sg13cmos5l_nor4_1
X_2515_ _2565_/B _2562_/C _3274_/C _2515_/C VPWR VGND sg13cmos5l_nand3_1
X_2446_ _2457_/D _2446_/A _2446_/B _2446_/C _2446_/D VPWR VGND sg13cmos5l_and4_1
X_2377_ _2378_/C _2524_/A _2429_/A VPWR VGND sg13cmos5l_nor2_1
XFILLER_24_244 VPWR VGND sg13cmos5l_fill_2
XFILLER_33_25 VPWR VGND sg13cmos5l_fill_2
XFILLER_33_47 VPWR VGND sg13cmos5l_fill_1
XFILLER_15_266 VPWR VGND sg13cmos5l_fill_2
X_2231_ _2235_/A _2352_/A _2352_/B VPWR VGND sg13cmos5l_nor2b_1
X_2300_ _2300_/Y _3046_/A _3254_/B _2086_/A _3065_/A VPWR VGND sg13cmos5l_a22oi_1
X_3280_ _3280_/Y _3282_/A _3279_/Y _3293_/A VPWR VGND sg13cmos5l_a21oi_1
XFILLER_24_4 VPWR VGND sg13cmos5l_fill_1
XFILLER_38_325 VPWR VGND sg13cmos5l_fill_1
X_2093_ _2094_/B _1774_/B _2244_/C _2092_/Y VPWR VGND sg13cmos5l_o21ai_1
X_2162_ _2499_/C _2175_/B _2436_/B VPWR VGND sg13cmos5l_nor2_1
X_2995_ _3039_/B _2992_/Y _2995_/B VPWR VGND sg13cmos5l_nand2b_1
X_1877_ _1877_/Y _3115_/A _1836_/A _1855_/A _2984_/A VPWR VGND sg13cmos5l_a22oi_1
X_1946_ _1949_/B _2639_/A _3014_/A _1946_/C VPWR VGND sg13cmos5l_nor3_1
X_2429_ _2449_/B _2429_/A _2429_/B _2429_/C _2429_/D VPWR VGND sg13cmos5l_nor4_1
XFILLER_44_24 VPWR VGND sg13cmos5l_decap_8
XFILLER_12_269 VPWR VGND sg13cmos5l_decap_8
XFILLER_20_280 VPWR VGND sg13cmos5l_fill_1
XFILLER_8_207 VPWR VGND sg13cmos5l_fill_2
Xclkbuf_5_16__f_clk _3419_/CLK clkbuf_4_8_0_clk/X VPWR VGND sg13cmos5l_buf_8
XFILLER_47_144 VPWR VGND sg13cmos5l_fill_1
XFILLER_47_177 VPWR VGND sg13cmos5l_fill_2
XFILLER_28_391 VPWR VGND sg13cmos5l_fill_2
X_1800_ _2992_/A _3046_/A _3065_/A VPWR VGND sg13cmos5l_nand2_1
X_1662_ _1662_/Y _2761_/A VPWR VGND sg13cmos5l_inv_1
X_1731_ _1731_/Y _2792_/B VPWR VGND sg13cmos5l_inv_1
Xhold207 _3419_/D _3416_/Q VPWR VGND sg13cmos5l_dlygate4sd3_1
Xhold218 _3344_/D _2686_/Y VPWR VGND sg13cmos5l_dlygate4sd3_1
Xhold229 _2873_/C _3392_/Q VPWR VGND sg13cmos5l_dlygate4sd3_1
X_3401_ _3401_/Q _3412_/CLK _3401_/D fanout184/X VPWR VGND sg13cmos5l_dfrbpq_1
X_2780_ _2791_/B _2832_/B VPWR VGND sg13cmos5l_inv_1
XFILLER_38_100 VPWR VGND sg13cmos5l_decap_8
X_2214_ _2379_/B _2213_/A _2214_/B VPWR VGND sg13cmos5l_nand2b_1
X_3332_ _3332_/Q _3379_/CLK _3332_/D fanout173/X VPWR VGND sg13cmos5l_dfrbpq_1
X_3263_ _3263_/X _3263_/A _3263_/B _3263_/C VPWR VGND sg13cmos5l_and3_1
X_3194_ _3194_/Y _3253_/A1 _1836_/A _1855_/A _3254_/A VPWR VGND sg13cmos5l_a22oi_1
XFILLER_15_0 VPWR VGND sg13cmos5l_fill_1
XFILLER_38_188 VPWR VGND sg13cmos5l_fill_1
X_2076_ _2092_/B _2076_/A _2079_/A VPWR VGND sg13cmos5l_xnor2_1
X_2145_ _2257_/A _2226_/A _2225_/A VPWR VGND sg13cmos5l_nand2b_1
XFILLER_14_27 VPWR VGND sg13cmos5l_fill_2
X_1929_ _1929_/Y _3050_/B _1816_/B VPWR VGND sg13cmos5l_nor2b_1
X_2978_ _2979_/B _2967_/A _2971_/Y _2977_/Y VPWR VGND sg13cmos5l_a21oi_1
XFILLER_29_155 VPWR VGND sg13cmos5l_decap_8
XFILLER_4_265 VPWR VGND sg13cmos5l_fill_1
XFILLER_4_276 VPWR VGND sg13cmos5l_fill_2
XFILLER_35_114 VPWR VGND sg13cmos5l_decap_8
XFILLER_35_136 VPWR VGND sg13cmos5l_decap_8
X_2901_ _2901_/Y _2908_/A _2907_/B _2908_/D VPWR VGND sg13cmos5l_nand3_1
X_2832_ _2835_/C _3276_/B _2832_/B VPWR VGND sg13cmos5l_nand2_1
X_2763_ _2763_/Y _2763_/A _2767_/B VPWR VGND sg13cmos5l_nand2_1
X_1714_ _1924_/B _3427_/Q _3425_/Q VPWR VGND sg13cmos5l_nor2_1
X_2694_ _2694_/Y _2694_/A _2751_/A _2699_/B _2694_/D VPWR VGND sg13cmos5l_nand4_1
X_3315_ _3315_/Q _3360_/CLK _3315_/D fanout166/X VPWR VGND sg13cmos5l_dfrbpq_1
X_3246_ _3246_/Y _3048_/B _2288_/Y _3245_/Y VPWR VGND sg13cmos5l_o21ai_1
X_3177_ _3178_/B _3175_/B _3176_/Y _3170_/Y VPWR VGND sg13cmos5l_a21oi_1
XFILLER_22_342 VPWR VGND sg13cmos5l_decap_8
XFILLER_34_180 VPWR VGND sg13cmos5l_fill_2
X_2059_ _2059_/Y _2446_/C _2059_/B _2249_/A VPWR VGND sg13cmos5l_nor3_1
X_2128_ _2510_/A _2274_/C _2351_/B VPWR VGND sg13cmos5l_nor2_1
XFILLER_41_36 VPWR VGND sg13cmos5l_decap_8
XFILLER_41_69 VPWR VGND sg13cmos5l_fill_1
XFILLER_13_320 VPWR VGND sg13cmos5l_fill_2
XFILLER_13_364 VPWR VGND sg13cmos5l_fill_2
XFILLER_25_180 VPWR VGND sg13cmos5l_fill_2
XFILLER_25_191 VPWR VGND sg13cmos5l_fill_1
XFILLER_32_106 VPWR VGND sg13cmos5l_decap_8
XFILLER_40_150 VPWR VGND sg13cmos5l_decap_4
XFILLER_40_183 VPWR VGND sg13cmos5l_fill_1
Xheichips26_heiscore_199 uio_out[3] VPWR VGND sg13cmos5l_tielo
X_3100_ _3100_/X _3100_/A _3181_/B _3100_/C VPWR VGND sg13cmos5l_or3_1
X_3031_ _3309_/D _3031_/A VPWR VGND sg13cmos5l_inv_1
X_2815_ _2815_/Y _3137_/A _2817_/C VPWR VGND sg13cmos5l_nor2_1
X_2746_ _2746_/X _2755_/A _2705_/Y _3357_/Q VPWR VGND sg13cmos5l_mux2_1
X_2677_ _2677_/Y _2677_/A _2677_/B _2677_/C VPWR VGND sg13cmos5l_nand3_1
X_3229_ _3229_/Y _3229_/A _3229_/B VPWR VGND sg13cmos5l_nor2_1
XFILLER_10_323 VPWR VGND sg13cmos5l_fill_2
XFILLER_22_161 VPWR VGND sg13cmos5l_fill_1
XFILLER_10_367 VPWR VGND sg13cmos5l_fill_2
XFILLER_45_242 VPWR VGND sg13cmos5l_fill_1
XFILLER_9_121 VPWR VGND sg13cmos5l_fill_2
X_2600_ _2604_/C _2600_/A _2606_/B VPWR VGND sg13cmos5l_xnor2_1
X_2531_ _2538_/C _2541_/A _2541_/B _2531_/C _2541_/D VPWR VGND sg13cmos5l_nand4_1
X_2462_ _2469_/A _2462_/A _2447_/D VPWR VGND sg13cmos5l_nor2b_1
X_2393_ _2394_/C _2400_/B _2405_/A _2393_/C VPWR VGND sg13cmos5l_nor3_1
XFILLER_28_209 VPWR VGND sg13cmos5l_fill_1
XFILLER_36_231 VPWR VGND sg13cmos5l_fill_1
X_3014_ _3014_/Y _3014_/A _3041_/B VPWR VGND sg13cmos5l_nor2_1
XFILLER_36_286 VPWR VGND sg13cmos5l_fill_2
X_2729_ _2729_/Y _1680_/Y _2767_/B _2713_/Y _2728_/X VPWR VGND sg13cmos5l_a22oi_1
Xfanout100 _3144_/A _3373_/Q VPWR VGND sg13cmos5l_buf_1
Xfanout111 _2734_/B _2761_/A VPWR VGND sg13cmos5l_buf_1
Xfanout122 _1934_/A _2084_/A VPWR VGND sg13cmos5l_buf_1
Xfanout133 _2594_/A _3330_/Q VPWR VGND sg13cmos5l_buf_1
Xfanout144 _3032_/A hold352/X VPWR VGND sg13cmos5l_buf_1
Xfanout155 _2972_/A hold377/X VPWR VGND sg13cmos5l_buf_1
Xfanout166 fanout166/X fanout168/X VPWR VGND sg13cmos5l_buf_1
Xfanout177 fanout177/X fanout188/X VPWR VGND sg13cmos5l_buf_1
Xfanout188 fanout188/X input1/X VPWR VGND sg13cmos5l_buf_1
XFILLER_27_297 VPWR VGND sg13cmos5l_fill_2
XFILLER_42_223 VPWR VGND sg13cmos5l_fill_1
XFILLER_10_186 VPWR VGND sg13cmos5l_fill_2
XFILLER_8_18 VPWR VGND sg13cmos5l_fill_2
XFILLER_18_220 VPWR VGND sg13cmos5l_decap_8
X_1962_ _1981_/C _2062_/A _1972_/A _2593_/A _1972_/B VPWR VGND sg13cmos5l_and4_1
X_1893_ _1893_/Y _1888_/X _1889_/Y _1892_/Y _1765_/Y _1890_/Y VPWR VGND sg13cmos5l_a221oi_1
XFILLER_45_0 VPWR VGND sg13cmos5l_decap_8
X_2514_ _2515_/C _2514_/A _2554_/B _2514_/C _2514_/D VPWR VGND sg13cmos5l_nor4_1
X_2445_ _2449_/C _2563_/A _3274_/C VPWR VGND sg13cmos5l_and2_1
X_2376_ _2429_/A _2376_/A _2468_/B _3286_/A VPWR VGND sg13cmos5l_or3_1
XFILLER_24_289 VPWR VGND sg13cmos5l_fill_1
XFILLER_15_245 VPWR VGND sg13cmos5l_decap_8
XFILLER_30_215 VPWR VGND sg13cmos5l_decap_4
XFILLER_30_248 VPWR VGND sg13cmos5l_fill_2
X_2230_ _2352_/B _2278_/B _2230_/B VPWR VGND sg13cmos5l_nand2b_1
XFILLER_0_52 VPWR VGND sg13cmos5l_fill_2
X_2092_ _2092_/Y _2092_/A _2092_/B _2092_/C _2092_/D VPWR VGND sg13cmos5l_nand4_1
X_2161_ _2389_/A _2555_/A _2540_/A VPWR VGND sg13cmos5l_nand2b_1
XFILLER_21_215 VPWR VGND sg13cmos5l_fill_2
XFILLER_9_72 VPWR VGND sg13cmos5l_fill_1
X_1945_ _1949_/A _1945_/A _1945_/B _1945_/C VPWR VGND sg13cmos5l_nor3_1
X_2994_ _2995_/B _3274_/B _2998_/A _2993_/Y _3028_/B VPWR VGND sg13cmos5l_a22oi_1
X_1876_ _1876_/X _1861_/Y _1873_/Y _1875_/Y VPWR VGND sg13cmos5l_a21o_1
X_2428_ _2429_/D _2428_/A _2543_/A _2428_/C _2518_/B VPWR VGND sg13cmos5l_nand4_1
X_2359_ _2455_/B _2274_/C _2195_/B _2242_/B VPWR VGND sg13cmos5l_o21ai_1
XFILLER_8_219 VPWR VGND sg13cmos5l_fill_1
XFILLER_34_91 VPWR VGND sg13cmos5l_decap_8
X_1661_ _1848_/A _1975_/A VPWR VGND sg13cmos5l_inv_1
X_1730_ _2792_/B _1730_/A _1736_/D VPWR VGND sg13cmos5l_and2_1
Xhold208 _3415_/D _3419_/Q VPWR VGND sg13cmos5l_dlygate4sd3_1
Xhold219 _2758_/A _3361_/Q VPWR VGND sg13cmos5l_dlygate4sd3_1
X_3400_ _3400_/Q _3413_/CLK _3400_/D fanout184/X VPWR VGND sg13cmos5l_dfrbpq_1
X_3331_ _3331_/Q _3419_/CLK _3331_/D fanout172/X VPWR VGND sg13cmos5l_dfrbpq_1
XFILLER_38_145 VPWR VGND sg13cmos5l_fill_2
X_2144_ _2225_/A _2522_/A _2543_/A VPWR VGND sg13cmos5l_and2_1
X_2213_ _2370_/B _2213_/A _2213_/B VPWR VGND sg13cmos5l_nor2_1
X_3262_ _3262_/Y _3262_/A _3268_/B VPWR VGND sg13cmos5l_nand2_1
X_3193_ _3193_/Y _3253_/A1 _1836_/A _3192_/Y VPWR VGND sg13cmos5l_o21ai_1
XFILLER_19_370 VPWR VGND sg13cmos5l_fill_2
X_2075_ _3277_/S _2485_/A _2487_/A VPWR VGND sg13cmos5l_nor2_1
Xclkbuf_5_22__f_clk _3342_/CLK clkbuf_4_11_0_clk/X VPWR VGND sg13cmos5l_buf_8
XFILLER_30_16 VPWR VGND sg13cmos5l_fill_2
X_1859_ _1860_/C _2314_/A _1859_/B _1859_/C VPWR VGND sg13cmos5l_nand3_1
X_1928_ _1928_/Y _1816_/A _3304_/Q VPWR VGND sg13cmos5l_nand2b_1
X_2977_ _2977_/Y _2971_/A _2318_/A _2935_/C VPWR VGND sg13cmos5l_a21oi_1
XFILLER_39_47 VPWR VGND sg13cmos5l_decap_4
XFILLER_29_178 VPWR VGND sg13cmos5l_fill_1
XFILLER_44_137 VPWR VGND sg13cmos5l_fill_2
XFILLER_45_90 VPWR VGND sg13cmos5l_fill_2
X_2900_ _2900_/Y _2896_/Y hold255/X _2908_/D VPWR VGND sg13cmos5l_o21ai_1
X_1713_ _3312_/D _1735_/A _1713_/B VPWR VGND sg13cmos5l_nand2b_1
X_2831_ _3268_/B _3276_/B _2832_/B VPWR VGND sg13cmos5l_and2_1
X_2762_ _3362_/D _2761_/A _2740_/A _2761_/Y VPWR VGND sg13cmos5l_o21ai_1
X_3314_ _3314_/Q _3360_/CLK _3314_/D fanout166/X VPWR VGND sg13cmos5l_dfrbpq_1
X_2693_ _2694_/D _3358_/Q _2693_/B _2755_/A VPWR VGND sg13cmos5l_nand3b_1
XFILLER_26_104 VPWR VGND sg13cmos5l_decap_8
X_2127_ _2516_/A _2240_/A _2415_/A VPWR VGND sg13cmos5l_and2_1
X_3245_ _3245_/Y _2322_/A _3183_/B _3181_/Y VPWR VGND sg13cmos5l_a21oi_1
X_3176_ _3176_/Y _3162_/Y _3163_/Y _3165_/Y VPWR VGND sg13cmos5l_a21oi_1
XFILLER_41_129 VPWR VGND sg13cmos5l_fill_1
X_2058_ _2249_/A _2446_/B _2071_/A VPWR VGND sg13cmos5l_nor2b_1
XFILLER_32_129 VPWR VGND sg13cmos5l_decap_4
XFILLER_40_162 VPWR VGND sg13cmos5l_decap_8
XFILLER_31_92 VPWR VGND sg13cmos5l_fill_1
Xheichips26_heiscore_189 uio_oe[1] VPWR VGND sg13cmos5l_tielo
X_3030_ _3031_/A _3028_/A _3006_/B _2997_/Y _3029_/Y VPWR VGND sg13cmos5l_a22oi_1
XFILLER_16_181 VPWR VGND sg13cmos5l_fill_2
XFILLER_11_18 VPWR VGND sg13cmos5l_fill_2
XFILLER_11_29 VPWR VGND sg13cmos5l_fill_2
X_2814_ _3374_/D _3146_/A _2808_/B _2813_/Y VPWR VGND sg13cmos5l_a21oi_1
X_2745_ _2745_/Y _1684_/Y _2758_/B _2713_/Y _2744_/Y VPWR VGND sg13cmos5l_a22oi_1
X_2676_ _3343_/D _2673_/A _2676_/A2 _2675_/Y VPWR VGND sg13cmos5l_a21o_1
X_3228_ _3228_/Y _3225_/Y _3226_/Y _3227_/Y VPWR VGND sg13cmos5l_o21ai_1
X_3159_ _3160_/C _3159_/A _3217_/B VPWR VGND sg13cmos5l_nand2_1
XFILLER_10_302 VPWR VGND sg13cmos5l_fill_1
XFILLER_22_173 VPWR VGND sg13cmos5l_fill_1
Xhold380 hold380/X _3366_/Q VPWR VGND sg13cmos5l_dlygate4sd3_1
XFILLER_9_133 VPWR VGND sg13cmos5l_fill_2
X_2530_ _2541_/D _2099_/X _2245_/B _2499_/B VPWR VGND sg13cmos5l_a21oi_1
XFILLER_47_4 VPWR VGND sg13cmos5l_fill_1
XFILLER_5_383 VPWR VGND sg13cmos5l_fill_2
X_2461_ _2563_/C _2538_/A _2461_/B VPWR VGND sg13cmos5l_nor2_1
X_2392_ _2393_/C _2392_/A _2497_/B _2459_/B _2392_/D VPWR VGND sg13cmos5l_nand4_1
XFILLER_36_243 VPWR VGND sg13cmos5l_fill_2
X_3013_ _3013_/Y _3014_/A _3041_/B VPWR VGND sg13cmos5l_nand2_1
XFILLER_22_28 VPWR VGND sg13cmos5l_fill_1
X_2728_ _2728_/X _2728_/A _2740_/A _2728_/C _2728_/D VPWR VGND sg13cmos5l_or4_1
X_2659_ _2659_/Y _2659_/A _2667_/B VPWR VGND sg13cmos5l_xnor2_1
Xfanout101 _3247_/A1 _3373_/Q VPWR VGND sg13cmos5l_buf_1
Xfanout112 _2761_/A hold337/X VPWR VGND sg13cmos5l_buf_1
Xfanout123 _2084_/A _3339_/Q VPWR VGND sg13cmos5l_buf_1
Xfanout134 _2586_/A hold373/X VPWR VGND sg13cmos5l_buf_1
Xfanout145 _3066_/A _3309_/Q VPWR VGND sg13cmos5l_buf_1
Xfanout156 _3105_/A _2963_/A VPWR VGND sg13cmos5l_buf_1
Xfanout167 fanout167/X fanout168/X VPWR VGND sg13cmos5l_buf_1
Xfanout178 fanout178/X fanout180/X VPWR VGND sg13cmos5l_buf_1
XFILLER_27_276 VPWR VGND sg13cmos5l_fill_2
XFILLER_10_132 VPWR VGND sg13cmos5l_fill_2
XFILLER_18_265 VPWR VGND sg13cmos5l_decap_8
Xclkbuf_5_3__f_clk _3364_/CLK clkbuf_4_1_0_clk/X VPWR VGND sg13cmos5l_buf_8
XFILLER_33_268 VPWR VGND sg13cmos5l_fill_2
X_1892_ _1892_/Y _3105_/A _2315_/A VPWR VGND sg13cmos5l_xnor2_1
X_1961_ _2060_/B _2068_/A _1972_/A _1972_/B VPWR VGND sg13cmos5l_nand3_1
X_2513_ _2514_/D _2513_/A _2535_/D _2513_/C _2513_/D VPWR VGND sg13cmos5l_nand4_1
XFILLER_38_0 VPWR VGND sg13cmos5l_decap_8
X_2444_ _3274_/C _3274_/A _2444_/B _2444_/C VPWR VGND sg13cmos5l_nand3_1
X_2375_ _2375_/Y _2375_/A _2443_/B VPWR VGND sg13cmos5l_nand2_1
XFILLER_33_38 VPWR VGND sg13cmos5l_decap_8
XFILLER_15_224 VPWR VGND sg13cmos5l_decap_8
X_2160_ _2555_/A _2413_/A _2280_/A _2542_/A VPWR VGND sg13cmos5l_o21ai_1
X_2091_ _2091_/Y _2315_/B _2315_/C VPWR VGND sg13cmos5l_nand2_1
X_1875_ _1875_/Y _2972_/A _3180_/B _1874_/Y VPWR VGND sg13cmos5l_o21ai_1
X_1944_ _1944_/Y _2085_/A _3028_/A VPWR VGND sg13cmos5l_nand2_1
X_2993_ _2993_/Y _3041_/A _3032_/A _2993_/C _2993_/D VPWR VGND sg13cmos5l_nor4_1
X_2427_ _2496_/A _2412_/A _2369_/A _2238_/D _2557_/B1 VPWR VGND sg13cmos5l_a22oi_1
XFILLER_28_49 VPWR VGND sg13cmos5l_decap_4
XFILLER_29_349 VPWR VGND sg13cmos5l_fill_1
X_2289_ _2289_/Y _3048_/A _2289_/B _2289_/C VPWR VGND sg13cmos5l_nand3_1
Xclkbuf_4_15_0_clk clkbuf_4_15_0_clk/X clkbuf_0_clk/X VPWR VGND sg13cmos5l_buf_8
X_2358_ _2459_/B _2522_/C _2358_/B VPWR VGND sg13cmos5l_nand2b_1
XFILLER_12_205 VPWR VGND sg13cmos5l_fill_2
XFILLER_12_227 VPWR VGND sg13cmos5l_decap_8
XFILLER_12_238 VPWR VGND sg13cmos5l_fill_1
XFILLER_12_249 VPWR VGND sg13cmos5l_decap_8
XFILLER_47_135 VPWR VGND sg13cmos5l_decap_4
XFILLER_47_179 VPWR VGND sg13cmos5l_fill_1
XFILLER_11_260 VPWR VGND sg13cmos5l_fill_1
XFILLER_7_253 VPWR VGND sg13cmos5l_decap_8
X_1660_ _1972_/A _3288_/A VPWR VGND sg13cmos5l_inv_1
Xhold209 _1735_/A _3312_/Q VPWR VGND sg13cmos5l_dlygate4sd3_1
X_3330_ _3330_/Q _3419_/CLK _3330_/D fanout173/X VPWR VGND sg13cmos5l_dfrbpq_1
XFILLER_38_168 VPWR VGND sg13cmos5l_decap_8
XFILLER_38_179 VPWR VGND sg13cmos5l_fill_1
X_2143_ _2543_/A _2557_/B1 _2238_/D _2499_/A VPWR VGND sg13cmos5l_a21oi_1
X_2212_ _2553_/A _2369_/C _2524_/B _2211_/Y VPWR VGND sg13cmos5l_a21oi_1
X_3261_ _3318_/D hold303/X _3268_/B _3260_/Y VPWR VGND sg13cmos5l_a21o_1
X_3192_ _3192_/Y _3189_/Y _3191_/Y _3180_/Y VPWR VGND sg13cmos5l_o21ai_1
XFILLER_19_382 VPWR VGND sg13cmos5l_decap_4
X_2074_ _2487_/A _2436_/A _2433_/A _2401_/C VPWR VGND sg13cmos5l_nor3_1
XFILLER_30_28 VPWR VGND sg13cmos5l_decap_8
X_1858_ _1859_/C _1797_/Y _1941_/B _1807_/Y VPWR VGND sg13cmos5l_o21ai_1
X_1927_ _1927_/Y _2628_/A _3050_/B VPWR VGND sg13cmos5l_nand2b_1
X_2976_ _2979_/A _2976_/A _2984_/B VPWR VGND sg13cmos5l_xnor2_1
XFILLER_39_26 VPWR VGND sg13cmos5l_decap_8
X_1789_ _2244_/B _1885_/A _2051_/B VPWR VGND sg13cmos5l_nand2_1
XFILLER_29_135 VPWR VGND sg13cmos5l_decap_8
XFILLER_44_116 VPWR VGND sg13cmos5l_fill_2
XFILLER_4_278 VPWR VGND sg13cmos5l_fill_1
XFILLER_16_330 VPWR VGND sg13cmos5l_fill_1
XFILLER_16_352 VPWR VGND sg13cmos5l_fill_2
XFILLER_16_363 VPWR VGND sg13cmos5l_decap_8
XFILLER_28_190 VPWR VGND sg13cmos5l_decap_4
XFILLER_31_322 VPWR VGND sg13cmos5l_fill_2
XFILLER_43_182 VPWR VGND sg13cmos5l_fill_2
X_2830_ _3379_/D _2830_/A _2830_/B VPWR VGND sg13cmos5l_nor2_1
X_1712_ _1735_/B _3369_/Q _1712_/B VPWR VGND sg13cmos5l_nand2_1
X_2761_ _2761_/Y _2761_/A _2767_/B VPWR VGND sg13cmos5l_nand2_1
X_2692_ _2753_/B _2689_/Y _2755_/B VPWR VGND sg13cmos5l_nand2b_1
X_3313_ _3313_/Q _3327_/CLK _3313_/D fanout166/X VPWR VGND sg13cmos5l_dfrbpq_1
X_3244_ _3257_/C _3244_/A _3244_/B VPWR VGND sg13cmos5l_nand2_1
X_2057_ _2059_/B _2057_/A _2057_/B VPWR VGND sg13cmos5l_nor2_1
X_2126_ _2415_/A _2213_/A _2147_/B VPWR VGND sg13cmos5l_nor2_1
X_3175_ _3178_/A _3175_/A _3175_/B _3175_/C _3175_/D VPWR VGND sg13cmos5l_nand4_1
XFILLER_34_182 VPWR VGND sg13cmos5l_fill_1
XFILLER_41_119 VPWR VGND sg13cmos5l_fill_2
XFILLER_41_16 VPWR VGND sg13cmos5l_fill_1
X_2959_ _2960_/B _3116_/A _2963_/B VPWR VGND sg13cmos5l_xnor2_1
XFILLER_1_215 VPWR VGND sg13cmos5l_fill_2
XFILLER_13_322 VPWR VGND sg13cmos5l_fill_1
XFILLER_13_366 VPWR VGND sg13cmos5l_fill_1
XFILLER_31_130 VPWR VGND sg13cmos5l_decap_8
X_2813_ _2813_/Y _2812_/A _2812_/B _2852_/B VPWR VGND sg13cmos5l_o21ai_1
X_2744_ _2744_/Y _2770_/A _2744_/B VPWR VGND sg13cmos5l_nand2_1
X_2675_ _2675_/Y _2672_/Y _2673_/Y _2674_/Y VPWR VGND sg13cmos5l_a21oi_1
XFILLER_39_241 VPWR VGND sg13cmos5l_fill_2
X_3227_ _3227_/Y _3204_/A _1974_/A _3224_/Y VPWR VGND sg13cmos5l_a21oi_1
X_2109_ _2902_/B _3400_/Q _2109_/B _2899_/B VPWR VGND sg13cmos5l_nor3_1
X_3158_ _3160_/B _3355_/Q _3166_/B _3167_/C _3157_/Y VPWR VGND sg13cmos5l_a22oi_1
X_3089_ _3138_/C _3089_/A _3089_/B _3272_/A VPWR VGND sg13cmos5l_or3_1
XFILLER_6_329 VPWR VGND sg13cmos5l_decap_8
Xhold370 hold370/X _3299_/Q VPWR VGND sg13cmos5l_dlygate4sd3_1
XFILLER_45_200 VPWR VGND sg13cmos5l_fill_1
X_2460_ _2460_/Y _2460_/A VPWR VGND sg13cmos5l_inv_1
X_2391_ _2392_/D _2551_/A _2421_/B _2391_/C VPWR VGND sg13cmos5l_nor3_1
XFILLER_36_211 VPWR VGND sg13cmos5l_decap_8
X_3012_ _3016_/A _3306_/Q _3028_/B _3009_/Y VPWR VGND sg13cmos5l_a21oi_1
Xfanout102 _3144_/C _3048_/B VPWR VGND sg13cmos5l_buf_1
Xfanout113 _2693_/B _3359_/Q VPWR VGND sg13cmos5l_buf_1
X_2727_ _2728_/D _3365_/Q _2727_/B VPWR VGND sg13cmos5l_nor2_1
X_2658_ _2658_/Y _2658_/A _2658_/B VPWR VGND sg13cmos5l_nand2_1
X_2589_ _3329_/D _2586_/A _3294_/A2 _2588_/Y VPWR VGND sg13cmos5l_a21o_1
XFILLER_47_15 VPWR VGND sg13cmos5l_decap_8
XFILLER_47_48 VPWR VGND sg13cmos5l_decap_8
XFILLER_47_59 VPWR VGND sg13cmos5l_fill_2
Xfanout124 _2028_/A _3338_/Q VPWR VGND sg13cmos5l_buf_1
Xfanout135 _2573_/A hold369/X VPWR VGND sg13cmos5l_buf_1
Xfanout146 _3028_/A hold374/X VPWR VGND sg13cmos5l_buf_1
Xfanout157 _2963_/A hold358/X VPWR VGND sg13cmos5l_buf_1
Xfanout168 fanout168/X fanout169/X VPWR VGND sg13cmos5l_buf_1
Xfanout179 fanout179/X fanout180/X VPWR VGND sg13cmos5l_buf_1
XFILLER_27_299 VPWR VGND sg13cmos5l_fill_1
XFILLER_10_188 VPWR VGND sg13cmos5l_fill_1
XFILLER_10_199 VPWR VGND sg13cmos5l_fill_2
XFILLER_12_40 VPWR VGND sg13cmos5l_fill_1
XFILLER_18_255 VPWR VGND sg13cmos5l_decap_4
XFILLER_33_214 VPWR VGND sg13cmos5l_decap_4
XFILLER_33_236 VPWR VGND sg13cmos5l_fill_2
X_1891_ _2326_/A _3105_/A _2315_/A VPWR VGND sg13cmos5l_xor2_1
X_1960_ _1973_/B _1972_/A _1972_/B VPWR VGND sg13cmos5l_nand2_1
X_2512_ _2513_/D _2512_/A _2512_/B _2512_/C VPWR VGND sg13cmos5l_nor3_1
X_2443_ _2563_/A hold380/X _2443_/B VPWR VGND sg13cmos5l_nand2b_1
X_2374_ _2656_/A _2375_/A _2443_/B VPWR VGND sg13cmos5l_and2_1
XFILLER_24_258 VPWR VGND sg13cmos5l_decap_4
X_2090_ _2092_/D _2315_/B _2315_/C VPWR VGND sg13cmos5l_and2_1
XFILLER_0_21 VPWR VGND sg13cmos5l_fill_1
XFILLER_21_217 VPWR VGND sg13cmos5l_fill_1
X_2992_ _2992_/Y _2992_/A _2992_/B _2992_/C VPWR VGND sg13cmos5l_nor3_1
X_1874_ _1874_/Y _2941_/B _1874_/B VPWR VGND sg13cmos5l_nand2_1
X_1943_ _1943_/Y _2659_/A _3065_/A VPWR VGND sg13cmos5l_nor2_1
X_2426_ _2429_/C _2486_/A _2486_/B VPWR VGND sg13cmos5l_nand2_1
XFILLER_44_16 VPWR VGND sg13cmos5l_decap_4
X_2288_ _2288_/Y _2289_/B _2289_/C VPWR VGND sg13cmos5l_nand2_1
X_2357_ _2485_/C _2497_/B _2357_/B VPWR VGND sg13cmos5l_nor2_1
XFILLER_44_49 VPWR VGND sg13cmos5l_decap_8
XFILLER_20_294 VPWR VGND sg13cmos5l_decap_4
XFILLER_47_125 VPWR VGND sg13cmos5l_decap_4
XFILLER_11_272 VPWR VGND sg13cmos5l_fill_2
XFILLER_11_294 VPWR VGND sg13cmos5l_decap_8
X_3260_ _3260_/Y _3179_/Y _3263_/C _2779_/Y VPWR VGND sg13cmos5l_a21oi_1
XFILLER_22_4 VPWR VGND sg13cmos5l_fill_2
XFILLER_38_114 VPWR VGND sg13cmos5l_decap_8
XFILLER_38_147 VPWR VGND sg13cmos5l_fill_1
X_2073_ _2401_/C _2061_/Y _2072_/Y _2620_/A VPWR VGND sg13cmos5l_o21ai_1
X_2142_ _2175_/B _2178_/A _2142_/B VPWR VGND sg13cmos5l_nand2_1
X_2211_ _2211_/Y _2435_/B _2175_/B _2773_/C VPWR VGND sg13cmos5l_o21ai_1
X_3191_ _3191_/Y _3180_/A _3180_/B _3190_/Y VPWR VGND sg13cmos5l_o21ai_1
X_2975_ _3301_/D _2972_/A _2950_/B _2974_/Y VPWR VGND sg13cmos5l_a21o_1
XFILLER_30_18 VPWR VGND sg13cmos5l_fill_1
X_1788_ _2051_/B _2586_/A _2573_/A VPWR VGND sg13cmos5l_and2_1
X_1857_ _1860_/B _1832_/Y _1835_/Y _1856_/Y VPWR VGND sg13cmos5l_a21oi_1
X_1926_ _1945_/A _2633_/A _2990_/B VPWR VGND sg13cmos5l_nor2_1
XFILLER_29_114 VPWR VGND sg13cmos5l_decap_8
X_3389_ _3389_/Q _3389_/CLK _3389_/D fanout177/X VPWR VGND sg13cmos5l_dfrbpq_1
X_2409_ _2431_/B _2408_/Y _2540_/B VPWR VGND sg13cmos5l_nand2b_1
XFILLER_17_309 VPWR VGND sg13cmos5l_fill_2
XFILLER_25_331 VPWR VGND sg13cmos5l_fill_2
XFILLER_37_180 VPWR VGND sg13cmos5l_decap_8
XFILLER_44_139 VPWR VGND sg13cmos5l_fill_1
XFILLER_35_128 VPWR VGND sg13cmos5l_fill_2
XFILLER_16_397 VPWR VGND sg13cmos5l_decap_8
X_1711_ _3417_/D _2792_/A VPWR VGND sg13cmos5l_inv_1
Xclkbuf_4_14_0_clk clkbuf_4_14_0_clk/X clkbuf_0_clk/X VPWR VGND sg13cmos5l_buf_8
X_2760_ _2760_/Y _2740_/A _2759_/Y _2758_/Y VPWR VGND sg13cmos5l_o21ai_1
X_2691_ _2755_/B _2750_/S _2691_/B VPWR VGND sg13cmos5l_nand2_1
X_3312_ _3312_/Q _3327_/CLK _3312_/D fanout166/X VPWR VGND sg13cmos5l_dfrbpq_1
X_3243_ _3244_/B _3389_/Q _1989_/B _3240_/B _3388_/Q VPWR VGND sg13cmos5l_a22oi_1
XFILLER_13_0 VPWR VGND sg13cmos5l_fill_1
XFILLER_22_301 VPWR VGND sg13cmos5l_decap_8
XFILLER_41_109 VPWR VGND sg13cmos5l_decap_4
X_2056_ _2446_/C _3212_/B _2052_/X _2055_/Y VPWR VGND sg13cmos5l_a21oi_1
X_2125_ _2939_/A input4/X input5/X _2269_/C VPWR VGND sg13cmos5l_nand3b_1
X_3174_ _3175_/D _3208_/A _3174_/B VPWR VGND sg13cmos5l_or2_1
XFILLER_22_312 VPWR VGND sg13cmos5l_fill_2
XFILLER_22_334 VPWR VGND sg13cmos5l_fill_2
X_1909_ _2539_/A _2351_/C _2351_/D _2544_/A VPWR VGND sg13cmos5l_o21ai_1
X_2958_ _2966_/A _3098_/A _2963_/B VPWR VGND sg13cmos5l_nand2_1
X_2889_ _2893_/B _3398_/Q _2889_/B _2889_/C VPWR VGND sg13cmos5l_or3_1
XFILLER_17_117 VPWR VGND sg13cmos5l_fill_2
XFILLER_31_50 VPWR VGND sg13cmos5l_decap_4
XFILLER_16_194 VPWR VGND sg13cmos5l_decap_8
XFILLER_31_153 VPWR VGND sg13cmos5l_decap_8
XFILLER_31_164 VPWR VGND sg13cmos5l_fill_2
X_2812_ _2817_/C _2812_/A _2812_/B VPWR VGND sg13cmos5l_nor2_1
X_2743_ _2744_/B _2761_/A _2728_/A _2727_/B _2742_/Y _2720_/D VPWR VGND sg13cmos5l_a221oi_1
X_2674_ _2674_/Y _2672_/Y _2673_/Y _2656_/A VPWR VGND sg13cmos5l_o21ai_1
XFILLER_36_17 VPWR VGND sg13cmos5l_decap_8
X_3226_ _3226_/Y _3381_/Q _1977_/B _3223_/Y VPWR VGND sg13cmos5l_o21ai_1
X_3157_ _3157_/Y _3157_/A _3171_/D VPWR VGND sg13cmos5l_nor2_1
X_2039_ _2040_/D _1972_/A _3224_/B _2038_/Y VPWR VGND sg13cmos5l_a21oi_1
X_2108_ _2926_/B _2908_/B _2908_/C _3406_/Q _2913_/A VPWR VGND sg13cmos5l_nor4_1
X_3088_ _3171_/C _3089_/A _3089_/B _3272_/A VPWR VGND sg13cmos5l_nor3_1
Xhold371 hold371/X _3298_/Q VPWR VGND sg13cmos5l_dlygate4sd3_1
Xhold360 _3365_/D _2771_/Y VPWR VGND sg13cmos5l_dlygate4sd3_1
XFILLER_45_234 VPWR VGND sg13cmos5l_fill_2
XFILLER_42_82 VPWR VGND sg13cmos5l_decap_4
XFILLER_5_363 VPWR VGND sg13cmos5l_fill_2
XFILLER_5_374 VPWR VGND sg13cmos5l_decap_4
XFILLER_3_87 VPWR VGND sg13cmos5l_fill_1
X_3011_ _3306_/D _3009_/Y _3010_/X _3006_/Y VPWR VGND sg13cmos5l_o21ai_1
X_2390_ _2391_/C _2390_/A _2390_/B _2447_/C _2430_/D VPWR VGND sg13cmos5l_nand4_1
XFILLER_36_245 VPWR VGND sg13cmos5l_fill_1
X_2726_ _2726_/X _2769_/A _2769_/C VPWR VGND sg13cmos5l_xor2_1
Xfanout103 _3048_/B _3372_/Q VPWR VGND sg13cmos5l_buf_1
Xfanout114 _2750_/S hold376/X VPWR VGND sg13cmos5l_buf_1
Xfanout125 _2007_/A _2634_/A VPWR VGND sg13cmos5l_buf_1
Xfanout136 _1999_/B _3288_/A VPWR VGND sg13cmos5l_buf_1
Xfanout147 _3055_/A _3308_/Q VPWR VGND sg13cmos5l_buf_1
Xclkbuf_5_28__f_clk _3394_/CLK clkbuf_4_14_0_clk/X VPWR VGND sg13cmos5l_buf_8
X_2657_ _3340_/D _2085_/A _2671_/A2 _2591_/Y _2656_/Y VPWR VGND sg13cmos5l_a22oi_1
X_2588_ _2588_/Y _2585_/Y _2586_/Y _2587_/Y VPWR VGND sg13cmos5l_a21oi_1
XFILLER_27_212 VPWR VGND sg13cmos5l_fill_2
XFILLER_27_234 VPWR VGND sg13cmos5l_decap_8
XFILLER_27_245 VPWR VGND sg13cmos5l_fill_1
Xfanout158 _3098_/A hold370/X VPWR VGND sg13cmos5l_buf_1
Xfanout169 fanout169/X fanout174/X VPWR VGND sg13cmos5l_buf_1
X_3209_ _3209_/Y _3206_/Y _3207_/Y _3208_/Y VPWR VGND sg13cmos5l_a21oi_1
XFILLER_18_201 VPWR VGND sg13cmos5l_fill_1
XFILLER_18_289 VPWR VGND sg13cmos5l_decap_8
XFILLER_37_71 VPWR VGND sg13cmos5l_decap_8
X_1890_ _1890_/Y _1863_/Y _1868_/X _1888_/B _1888_/A _1866_/Y VPWR VGND sg13cmos5l_a221oi_1
X_2511_ _2512_/C _2376_/A _2541_/B VPWR VGND sg13cmos5l_nand2b_1
X_2442_ _3425_/D _2449_/B _2456_/B _2442_/C VPWR VGND sg13cmos5l_nand3_1
X_2373_ _2390_/A _2455_/C _2373_/B _2373_/C VPWR VGND sg13cmos5l_nor3_1
XFILLER_24_204 VPWR VGND sg13cmos5l_fill_2
XFILLER_24_226 VPWR VGND sg13cmos5l_fill_2
XFILLER_24_237 VPWR VGND sg13cmos5l_decap_8
XFILLER_33_18 VPWR VGND sg13cmos5l_decap_8
X_2709_ _2710_/D _2689_/Y _2701_/Y _2755_/A VPWR VGND sg13cmos5l_o21ai_1
XFILLER_15_259 VPWR VGND sg13cmos5l_decap_8
XFILLER_23_51 VPWR VGND sg13cmos5l_fill_1
Xclkbuf_5_11__f_clk _3373_/CLK clkbuf_4_5_0_clk/X VPWR VGND sg13cmos5l_buf_8
XFILLER_0_66 VPWR VGND sg13cmos5l_fill_2
XFILLER_0_77 VPWR VGND sg13cmos5l_fill_1
X_1942_ _1942_/Y _2667_/A _3041_/A _3065_/A _2659_/A VPWR VGND sg13cmos5l_a22oi_1
X_2991_ _2992_/C _3019_/A _2990_/Y _3028_/A VPWR VGND sg13cmos5l_a21oi_1
X_1873_ _1873_/Y _1869_/Y _1871_/Y _1872_/Y VPWR VGND sg13cmos5l_o21ai_1
XFILLER_43_0 VPWR VGND sg13cmos5l_decap_4
X_2425_ _2486_/B _2935_/C _2425_/B VPWR VGND sg13cmos5l_and2_1
X_2356_ _2441_/A _2457_/A _2392_/A VPWR VGND sg13cmos5l_nand2b_1
X_2287_ _2293_/B _3008_/A _2320_/B VPWR VGND sg13cmos5l_nor2_1
XFILLER_20_273 VPWR VGND sg13cmos5l_fill_2
XFILLER_34_61 VPWR VGND sg13cmos5l_decap_4
XFILLER_43_376 VPWR VGND sg13cmos5l_fill_2
XFILLER_7_233 VPWR VGND sg13cmos5l_decap_4
XFILLER_7_266 VPWR VGND sg13cmos5l_fill_2
XFILLER_7_277 VPWR VGND sg13cmos5l_fill_1
XFILLER_7_299 VPWR VGND sg13cmos5l_fill_2
X_2210_ _2773_/C _2450_/A _2245_/B VPWR VGND sg13cmos5l_nand2_1
X_3190_ _3190_/Y _3190_/A _3190_/B VPWR VGND sg13cmos5l_nand2_1
X_2072_ _2072_/Y _2072_/A _2072_/B _2072_/C _2072_/D VPWR VGND sg13cmos5l_nor4_1
X_2141_ _2238_/D _2178_/A _2142_/B VPWR VGND sg13cmos5l_and2_1
X_1925_ _1955_/B _1941_/B _1941_/C _2667_/A VPWR VGND sg13cmos5l_a21oi_1
X_2974_ _2974_/Y _2970_/Y _2972_/Y _2973_/Y VPWR VGND sg13cmos5l_a21oi_1
X_1787_ _1885_/A _2062_/A _2054_/A _2063_/A VPWR VGND sg13cmos5l_nor3_1
X_1856_ _1856_/Y _1856_/A _1856_/B _1856_/C VPWR VGND sg13cmos5l_nand3_1
X_3388_ _3388_/Q _3388_/CLK _3388_/D fanout177/X VPWR VGND sg13cmos5l_dfrbpq_1
X_2408_ _2408_/Y _2180_/Y _2279_/B _2562_/B VPWR VGND sg13cmos5l_o21ai_1
X_2339_ _2339_/Y _3303_/Q _3254_/B _2086_/A _3115_/A VPWR VGND sg13cmos5l_a22oi_1
XFILLER_44_118 VPWR VGND sg13cmos5l_fill_1
XFILLER_4_247 VPWR VGND sg13cmos5l_fill_2
XFILLER_35_107 VPWR VGND sg13cmos5l_decap_8
XFILLER_43_140 VPWR VGND sg13cmos5l_decap_8
XFILLER_43_151 VPWR VGND sg13cmos5l_fill_1
XFILLER_43_184 VPWR VGND sg13cmos5l_fill_1
X_1710_ _2782_/B _3168_/C VPWR VGND sg13cmos5l_inv_1
Xclkbuf_5_9__f_clk clkload2/A clkbuf_4_4_0_clk/X VPWR VGND sg13cmos5l_buf_8
X_3311_ _3311_/Q _3342_/CLK _3311_/D fanout182/X VPWR VGND sg13cmos5l_dfrbpq_1
X_2690_ _2691_/B _3358_/Q _2693_/B VPWR VGND sg13cmos5l_and2_1
X_2124_ _2269_/C _2433_/A _2208_/A VPWR VGND sg13cmos5l_nor2_1
X_3242_ _3244_/A _3242_/A _3242_/B VPWR VGND sg13cmos5l_nand2_1
X_3173_ _3175_/C _3173_/A _3173_/B VPWR VGND sg13cmos5l_nand2_1
XFILLER_19_181 VPWR VGND sg13cmos5l_decap_4
XFILLER_34_140 VPWR VGND sg13cmos5l_decap_4
X_2055_ _2055_/Y _2063_/B _2055_/B _2071_/A VPWR VGND sg13cmos5l_nand3b_1
XFILLER_22_368 VPWR VGND sg13cmos5l_fill_1
XFILLER_34_195 VPWR VGND sg13cmos5l_fill_1
XFILLER_41_29 VPWR VGND sg13cmos5l_decap_8
X_1839_ _1839_/Y _1808_/Y _1810_/Y _1825_/A _1837_/Y _1838_/X VPWR VGND sg13cmos5l_a221oi_1
X_1908_ _1916_/C _1908_/A _1908_/B _1908_/C _1908_/D VPWR VGND sg13cmos5l_nor4_1
X_2957_ _2960_/A _2952_/A _2963_/B _2953_/Y VPWR VGND sg13cmos5l_a21oi_1
X_2888_ _3398_/D hold318/X _2889_/C _2887_/Y VPWR VGND sg13cmos5l_a21o_1
XFILLER_40_121 VPWR VGND sg13cmos5l_decap_8
XFILLER_40_143 VPWR VGND sg13cmos5l_decap_8
XFILLER_40_154 VPWR VGND sg13cmos5l_fill_2
XFILLER_40_176 VPWR VGND sg13cmos5l_decap_8
XFILLER_16_162 VPWR VGND sg13cmos5l_decap_8
XFILLER_12_390 VPWR VGND sg13cmos5l_fill_2
XFILLER_31_187 VPWR VGND sg13cmos5l_decap_4
XFILLER_8_350 VPWR VGND sg13cmos5l_fill_1
X_2811_ _2812_/B _3138_/B _3269_/C _3130_/B VPWR VGND sg13cmos5l_nand3_1
X_2742_ _2742_/Y _2769_/B _2769_/C VPWR VGND sg13cmos5l_nor2_1
XFILLER_8_383 VPWR VGND sg13cmos5l_fill_1
X_2673_ _2673_/Y _2673_/A _2673_/B VPWR VGND sg13cmos5l_xnor2_1
XFILLER_39_221 VPWR VGND sg13cmos5l_decap_4
XFILLER_39_243 VPWR VGND sg13cmos5l_fill_1
X_2107_ _2926_/A _3408_/Q _3409_/Q _3410_/Q _2925_/A VPWR VGND sg13cmos5l_nor4_1
X_3225_ _3225_/Y _1975_/A _3381_/Q _3200_/B VPWR VGND sg13cmos5l_a21oi_1
X_3156_ _3179_/B _3156_/A _3265_/B _3156_/C _3156_/D VPWR VGND sg13cmos5l_nor4_1
X_3087_ _3087_/Y _3089_/A _3089_/B _3087_/C _3217_/C VPWR VGND sg13cmos5l_nand4_1
XFILLER_22_121 VPWR VGND sg13cmos5l_decap_8
XFILLER_22_132 VPWR VGND sg13cmos5l_fill_2
X_2038_ _2038_/Y _2060_/C _3224_/B VPWR VGND sg13cmos5l_nor2_1
XFILLER_6_309 VPWR VGND sg13cmos5l_fill_2
Xhold372 _2577_/A _3325_/Q VPWR VGND sg13cmos5l_dlygate4sd3_1
Xhold361 hold361/X _3384_/Q VPWR VGND sg13cmos5l_dlygate4sd3_1
Xhold350 hold350/X _3326_/Q VPWR VGND sg13cmos5l_dlygate4sd3_1
Xclkbuf_4_13_0_clk clkbuf_4_13_0_clk/X clkbuf_0_clk/X VPWR VGND sg13cmos5l_buf_8
X_3010_ _3010_/X _3009_/A _3009_/B _3023_/A VPWR VGND sg13cmos5l_a21o_1
X_2725_ _2725_/Y _2763_/A _2738_/B VPWR VGND sg13cmos5l_nand2_1
X_2656_ _2656_/Y _2656_/A _2658_/B _2656_/C VPWR VGND sg13cmos5l_nand3_1
Xfanout104 _3269_/B _3181_/B VPWR VGND sg13cmos5l_buf_1
Xfanout115 _2076_/A _3343_/Q VPWR VGND sg13cmos5l_buf_1
Xfanout126 _2633_/A _2634_/A VPWR VGND sg13cmos5l_buf_1
Xfanout137 _3288_/A hold362/X VPWR VGND sg13cmos5l_buf_1
Xfanout148 _3019_/A hold351/X VPWR VGND sg13cmos5l_buf_1
Xfanout159 _2315_/A _3299_/Q VPWR VGND sg13cmos5l_buf_1
X_2587_ _2587_/Y _2585_/Y _2586_/Y _3286_/A VPWR VGND sg13cmos5l_o21ai_1
X_3208_ _3208_/Y _3208_/A _3208_/B VPWR VGND sg13cmos5l_nor2_1
X_3139_ _3139_/Y _3361_/Q _3136_/Y _3138_/Y _3350_/Q VPWR VGND sg13cmos5l_a22oi_1
XFILLER_12_53 VPWR VGND sg13cmos5l_fill_2
XFILLER_2_312 VPWR VGND sg13cmos5l_fill_1
XFILLER_18_213 VPWR VGND sg13cmos5l_decap_8
XFILLER_37_50 VPWR VGND sg13cmos5l_fill_2
XFILLER_33_238 VPWR VGND sg13cmos5l_fill_1
X_2510_ _2513_/C _2510_/A _2510_/B _2510_/C _2510_/D VPWR VGND sg13cmos5l_nor4_1
X_2441_ _2442_/C _2441_/A _2561_/A _2441_/C _2441_/D VPWR VGND sg13cmos5l_nor4_1
X_2372_ _2373_/C _2476_/C _2541_/B _2372_/C VPWR VGND sg13cmos5l_nand3_1
X_2708_ _2708_/Y _1689_/Y _2685_/Y _2707_/Y _2678_/Y VPWR VGND sg13cmos5l_a22oi_1
X_2639_ _2641_/A _2639_/A _2673_/B VPWR VGND sg13cmos5l_xnor2_1
XFILLER_30_219 VPWR VGND sg13cmos5l_fill_1
XFILLER_14_282 VPWR VGND sg13cmos5l_fill_2
X_1872_ _1872_/Y _2318_/A _1889_/B VPWR VGND sg13cmos5l_nand2_1
X_1941_ _1955_/C _2667_/A _1941_/B _1941_/C VPWR VGND sg13cmos5l_and3_1
X_2990_ _2990_/Y _3015_/A _2990_/B _3048_/A VPWR VGND sg13cmos5l_nand3_1
XFILLER_36_0 VPWR VGND sg13cmos5l_decap_8
X_2286_ _2286_/Y _2286_/A _2289_/B VPWR VGND sg13cmos5l_xnor2_1
X_2424_ _3424_/D _2456_/A _2424_/B VPWR VGND sg13cmos5l_nand2_1
X_2355_ _2405_/A _2542_/B _2355_/B VPWR VGND sg13cmos5l_nand2_1
XFILLER_18_85 VPWR VGND sg13cmos5l_fill_1
XFILLER_34_84 VPWR VGND sg13cmos5l_decap_8
XFILLER_11_274 VPWR VGND sg13cmos5l_fill_1
X_2140_ _2499_/A _2196_/A _2435_/B VPWR VGND sg13cmos5l_nor2_1
XFILLER_19_363 VPWR VGND sg13cmos5l_decap_8
XFILLER_38_138 VPWR VGND sg13cmos5l_decap_8
X_2071_ _2072_/D _2071_/A _2071_/B VPWR VGND sg13cmos5l_nand2_1
X_1855_ _1856_/C _1855_/A _3059_/B VPWR VGND sg13cmos5l_xnor2_1
X_1924_ _2433_/A _2098_/A _1924_/B VPWR VGND sg13cmos5l_nand2_1
X_2973_ _2973_/Y _2970_/Y _2972_/Y _2980_/A VPWR VGND sg13cmos5l_o21ai_1
X_1786_ _2244_/A _2037_/A _1975_/A _1999_/B VPWR VGND sg13cmos5l_a21oi_1
XFILLER_29_149 VPWR VGND sg13cmos5l_fill_1
X_2269_ _2556_/B input4/X _2269_/B _2269_/C VPWR VGND sg13cmos5l_nand3b_1
X_2338_ _2338_/Y _3115_/A _2086_/A _2337_/X VPWR VGND sg13cmos5l_o21ai_1
X_3387_ _3387_/Q _3389_/CLK _3387_/D fanout171/X VPWR VGND sg13cmos5l_dfrbpq_1
X_2407_ _2561_/A _2407_/A _2520_/B VPWR VGND sg13cmos5l_nor2b_1
XFILLER_25_311 VPWR VGND sg13cmos5l_decap_4
XFILLER_25_366 VPWR VGND sg13cmos5l_fill_1
XFILLER_29_40 VPWR VGND sg13cmos5l_decap_8
XFILLER_4_259 VPWR VGND sg13cmos5l_fill_1
XFILLER_16_300 VPWR VGND sg13cmos5l_fill_2
XFILLER_16_311 VPWR VGND sg13cmos5l_decap_4
XFILLER_16_344 VPWR VGND sg13cmos5l_fill_2
XFILLER_43_196 VPWR VGND sg13cmos5l_fill_2
XFILLER_6_44 VPWR VGND sg13cmos5l_fill_2
X_3310_ _3310_/Q _3335_/CLK _3310_/D fanout187/X VPWR VGND sg13cmos5l_dfrbpq_1
X_2123_ _2208_/A _2214_/B _2178_/B VPWR VGND sg13cmos5l_nand2_1
X_3241_ _3242_/B _3235_/A _3235_/B _3240_/Y VPWR VGND sg13cmos5l_a21oi_1
X_3172_ _3173_/B _3356_/Q _3136_/Y _3138_/Y _3344_/Q VPWR VGND sg13cmos5l_a22oi_1
X_2054_ _2063_/B _2054_/A _2054_/B VPWR VGND sg13cmos5l_xnor2_1
X_1838_ _1838_/X _3066_/A _1838_/B VPWR VGND sg13cmos5l_and2_1
X_1907_ _1908_/D _1902_/Y _1904_/Y _1906_/Y VPWR VGND sg13cmos5l_a21oi_1
X_2956_ _3298_/D _2953_/Y _2955_/Y _2950_/Y VPWR VGND sg13cmos5l_o21ai_1
X_2887_ _2887_/Y hold318/X _2889_/C _2925_/B VPWR VGND sg13cmos5l_o21ai_1
X_1769_ _1874_/B _2032_/A _1773_/A VPWR VGND sg13cmos5l_xnor2_1
XFILLER_9_329 VPWR VGND sg13cmos5l_fill_1
XFILLER_31_74 VPWR VGND sg13cmos5l_decap_4
Xoutput6 uo_out[0] _3447_/X VPWR VGND sg13cmos5l_buf_1
XFILLER_16_174 VPWR VGND sg13cmos5l_decap_8
XFILLER_31_144 VPWR VGND sg13cmos5l_fill_2
X_2810_ _3130_/B _3144_/A _2810_/B VPWR VGND sg13cmos5l_and2_1
X_2741_ _2741_/Y _3157_/A _2758_/B _2713_/Y _2740_/X VPWR VGND sg13cmos5l_a22oi_1
X_2672_ _2672_/Y hold296/X _2667_/B _2670_/A VPWR VGND sg13cmos5l_a21oi_1
XFILLER_39_200 VPWR VGND sg13cmos5l_decap_8
X_3224_ _3224_/Y _3224_/A _3224_/B VPWR VGND sg13cmos5l_nor2_1
.ends
